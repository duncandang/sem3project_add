* NGSPICE file created from dual_sensor_top.ext - technology: sky130A

* Black-box entry subcircuit for sky130_fd_sc_hd__fill_2 abstract view
.subckt sky130_fd_sc_hd__fill_2 VGND VNB VPB VPWR
.ends

* Black-box entry subcircuit for sky130_fd_sc_hd__decap_3 abstract view
.subckt sky130_fd_sc_hd__decap_3 VGND VNB VPB VPWR
.ends

* Black-box entry subcircuit for sky130_fd_sc_hd__tapvpwrvgnd_1 abstract view
.subckt sky130_fd_sc_hd__tapvpwrvgnd_1 VGND VPWR
.ends

* Black-box entry subcircuit for sky130_ef_sc_hd__decap_12 abstract view
.subckt sky130_ef_sc_hd__decap_12 VPWR VGND VPB VNB
.ends

* Black-box entry subcircuit for sky130_fd_sc_hd__decap_4 abstract view
.subckt sky130_fd_sc_hd__decap_4 VGND VNB VPB VPWR
.ends

* Black-box entry subcircuit for sky130_fd_sc_hd__nor2_4 abstract view
.subckt sky130_fd_sc_hd__nor2_4 A B VGND VNB VPB VPWR Y
.ends

* Black-box entry subcircuit for sky130_fd_sc_hd__dfxtp_1 abstract view
.subckt sky130_fd_sc_hd__dfxtp_1 CLK D VGND VNB VPB VPWR Q
.ends

* Black-box entry subcircuit for sky130_fd_sc_hd__xor2_1 abstract view
.subckt sky130_fd_sc_hd__xor2_1 A B VGND VNB VPB VPWR X
.ends

* Black-box entry subcircuit for sky130_fd_sc_hd__a21oi_1 abstract view
.subckt sky130_fd_sc_hd__a21oi_1 A1 A2 B1 VGND VNB VPB VPWR Y
.ends

* Black-box entry subcircuit for sky130_fd_sc_hd__and3b_1 abstract view
.subckt sky130_fd_sc_hd__and3b_1 A_N B C VGND VNB VPB VPWR X
.ends

* Black-box entry subcircuit for sky130_fd_sc_hd__dfrtp_1 abstract view
.subckt sky130_fd_sc_hd__dfrtp_1 CLK D RESET_B VGND VNB VPB VPWR Q
.ends

* Black-box entry subcircuit for sky130_fd_sc_hd__decap_8 abstract view
.subckt sky130_fd_sc_hd__decap_8 VGND VNB VPB VPWR
.ends

* Black-box entry subcircuit for sky130_fd_sc_hd__dlygate4sd3_1 abstract view
.subckt sky130_fd_sc_hd__dlygate4sd3_1 A VGND VNB VPB VPWR X
.ends

* Black-box entry subcircuit for sky130_fd_sc_hd__decap_6 abstract view
.subckt sky130_fd_sc_hd__decap_6 VGND VNB VPB VPWR
.ends

* Black-box entry subcircuit for sky130_fd_sc_hd__a2111o_1 abstract view
.subckt sky130_fd_sc_hd__a2111o_1 A1 A2 B1 C1 D1 VGND VNB VPB VPWR X
.ends

* Black-box entry subcircuit for sky130_fd_sc_hd__nand2_1 abstract view
.subckt sky130_fd_sc_hd__nand2_1 A B VGND VNB VPB VPWR Y
.ends

* Black-box entry subcircuit for sky130_fd_sc_hd__clkbuf_8 abstract view
.subckt sky130_fd_sc_hd__clkbuf_8 A VGND VNB VPB VPWR X
.ends

* Black-box entry subcircuit for sky130_fd_sc_hd__mux2_1 abstract view
.subckt sky130_fd_sc_hd__mux2_1 A0 A1 S VGND VNB VPB VPWR X
.ends

* Black-box entry subcircuit for sky130_fd_sc_hd__inv_2 abstract view
.subckt sky130_fd_sc_hd__inv_2 A VGND VNB VPB VPWR Y
.ends

* Black-box entry subcircuit for sky130_fd_sc_hd__a22o_1 abstract view
.subckt sky130_fd_sc_hd__a22o_1 A1 A2 B1 B2 VGND VNB VPB VPWR X
.ends

* Black-box entry subcircuit for sky130_fd_sc_hd__or2_1 abstract view
.subckt sky130_fd_sc_hd__or2_1 A B VGND VNB VPB VPWR X
.ends

* Black-box entry subcircuit for sky130_fd_sc_hd__nand2b_1 abstract view
.subckt sky130_fd_sc_hd__nand2b_1 A_N B VGND VNB VPB VPWR Y
.ends

* Black-box entry subcircuit for sky130_fd_sc_hd__fill_1 abstract view
.subckt sky130_fd_sc_hd__fill_1 VGND VNB VPB VPWR
.ends

* Black-box entry subcircuit for sky130_fd_sc_hd__a32o_1 abstract view
.subckt sky130_fd_sc_hd__a32o_1 A1 A2 A3 B1 B2 VGND VNB VPB VPWR X
.ends

* Black-box entry subcircuit for sky130_fd_sc_hd__buf_2 abstract view
.subckt sky130_fd_sc_hd__buf_2 A VGND VNB VPB VPWR X
.ends

* Black-box entry subcircuit for sky130_fd_sc_hd__o21a_1 abstract view
.subckt sky130_fd_sc_hd__o21a_1 A1 A2 B1 VGND VNB VPB VPWR X
.ends

* Black-box entry subcircuit for sky130_fd_sc_hd__a311o_1 abstract view
.subckt sky130_fd_sc_hd__a311o_1 A1 A2 A3 B1 C1 VGND VNB VPB VPWR X
.ends

* Black-box entry subcircuit for sky130_fd_sc_hd__a221o_1 abstract view
.subckt sky130_fd_sc_hd__a221o_1 A1 A2 B1 B2 C1 VGND VNB VPB VPWR X
.ends

* Black-box entry subcircuit for sky130_fd_sc_hd__and4_4 abstract view
.subckt sky130_fd_sc_hd__and4_4 A B C D VGND VNB VPB VPWR X
.ends

* Black-box entry subcircuit for sky130_fd_sc_hd__o2bb2a_1 abstract view
.subckt sky130_fd_sc_hd__o2bb2a_1 A1_N A2_N B1 B2 VGND VNB VPB VPWR X
.ends

* Black-box entry subcircuit for sky130_fd_sc_hd__and3_1 abstract view
.subckt sky130_fd_sc_hd__and3_1 A B C VGND VNB VPB VPWR X
.ends

* Black-box entry subcircuit for sky130_fd_sc_hd__and3_4 abstract view
.subckt sky130_fd_sc_hd__and3_4 A B C VGND VNB VPB VPWR X
.ends

* Black-box entry subcircuit for sky130_fd_sc_hd__o21ba_1 abstract view
.subckt sky130_fd_sc_hd__o21ba_1 A1 A2 B1_N VGND VNB VPB VPWR X
.ends

* Black-box entry subcircuit for sky130_fd_sc_hd__a21o_1 abstract view
.subckt sky130_fd_sc_hd__a21o_1 A1 A2 B1 VGND VNB VPB VPWR X
.ends

* Black-box entry subcircuit for sky130_fd_sc_hd__a21bo_1 abstract view
.subckt sky130_fd_sc_hd__a21bo_1 A1 A2 B1_N VGND VNB VPB VPWR X
.ends

* Black-box entry subcircuit for sky130_fd_sc_hd__nor2_1 abstract view
.subckt sky130_fd_sc_hd__nor2_1 A B VGND VNB VPB VPWR Y
.ends

* Black-box entry subcircuit for sky130_fd_sc_hd__o32a_1 abstract view
.subckt sky130_fd_sc_hd__o32a_1 A1 A2 A3 B1 B2 VGND VNB VPB VPWR X
.ends

* Black-box entry subcircuit for sky130_fd_sc_hd__a31oi_1 abstract view
.subckt sky130_fd_sc_hd__a31oi_1 A1 A2 A3 B1 VGND VNB VPB VPWR Y
.ends

* Black-box entry subcircuit for sky130_fd_sc_hd__a31o_1 abstract view
.subckt sky130_fd_sc_hd__a31o_1 A1 A2 A3 B1 VGND VNB VPB VPWR X
.ends

* Black-box entry subcircuit for sky130_fd_sc_hd__o22a_1 abstract view
.subckt sky130_fd_sc_hd__o22a_1 A1 A2 B1 B2 VGND VNB VPB VPWR X
.ends

* Black-box entry subcircuit for sky130_fd_sc_hd__or3b_1 abstract view
.subckt sky130_fd_sc_hd__or3b_1 A B C_N VGND VNB VPB VPWR X
.ends

* Black-box entry subcircuit for sky130_fd_sc_hd__ebufn_8 abstract view
.subckt sky130_fd_sc_hd__ebufn_8 A TE_B VGND VNB VPB VPWR Z
.ends

* Black-box entry subcircuit for sky130_fd_sc_hd__clkbuf_16 abstract view
.subckt sky130_fd_sc_hd__clkbuf_16 A VGND VNB VPB VPWR X
.ends

* Black-box entry subcircuit for sky130_fd_sc_hd__and4b_4 abstract view
.subckt sky130_fd_sc_hd__and4b_4 A_N B C D VGND VNB VPB VPWR X
.ends

* Black-box entry subcircuit for sky130_fd_sc_hd__dfrtp_4 abstract view
.subckt sky130_fd_sc_hd__dfrtp_4 CLK D RESET_B VGND VNB VPB VPWR Q
.ends

* Black-box entry subcircuit for sky130_fd_sc_hd__nor3_1 abstract view
.subckt sky130_fd_sc_hd__nor3_1 A B C VGND VNB VPB VPWR Y
.ends

* Black-box entry subcircuit for sky130_fd_sc_hd__and4_2 abstract view
.subckt sky130_fd_sc_hd__and4_2 A B C D VGND VNB VPB VPWR X
.ends

* Black-box entry subcircuit for sky130_fd_sc_hd__and4_1 abstract view
.subckt sky130_fd_sc_hd__and4_1 A B C D VGND VNB VPB VPWR X
.ends

* Black-box entry subcircuit for sky130_fd_sc_hd__and2_1 abstract view
.subckt sky130_fd_sc_hd__and2_1 A B VGND VNB VPB VPWR X
.ends

* Black-box entry subcircuit for sky130_fd_sc_hd__o211a_1 abstract view
.subckt sky130_fd_sc_hd__o211a_1 A1 A2 B1 C1 VGND VNB VPB VPWR X
.ends

* Black-box entry subcircuit for sky130_fd_sc_hd__a21oi_2 abstract view
.subckt sky130_fd_sc_hd__a21oi_2 A1 A2 B1 VGND VNB VPB VPWR Y
.ends

* Black-box entry subcircuit for sky130_fd_sc_hd__clkbuf_1 abstract view
.subckt sky130_fd_sc_hd__clkbuf_1 A VGND VNB VPB VPWR X
.ends

* Black-box entry subcircuit for sky130_fd_sc_hd__conb_1 abstract view
.subckt sky130_fd_sc_hd__conb_1 VGND VNB VPB VPWR HI LO
.ends

* Black-box entry subcircuit for sky130_fd_sc_hd__or4_1 abstract view
.subckt sky130_fd_sc_hd__or4_1 A B C D VGND VNB VPB VPWR X
.ends

* Black-box entry subcircuit for sky130_fd_sc_hd__nand4_2 abstract view
.subckt sky130_fd_sc_hd__nand4_2 A B C D VGND VNB VPB VPWR Y
.ends

* Black-box entry subcircuit for sky130_fd_sc_hd__o31a_1 abstract view
.subckt sky130_fd_sc_hd__o31a_1 A1 A2 A3 B1 VGND VNB VPB VPWR X
.ends

* Black-box entry subcircuit for sky130_fd_sc_hd__dfrtp_2 abstract view
.subckt sky130_fd_sc_hd__dfrtp_2 CLK D RESET_B VGND VNB VPB VPWR Q
.ends

* Black-box entry subcircuit for sky130_fd_sc_hd__nand3_1 abstract view
.subckt sky130_fd_sc_hd__nand3_1 A B C VGND VNB VPB VPWR Y
.ends

* Black-box entry subcircuit for sky130_fd_sc_hd__xnor2_1 abstract view
.subckt sky130_fd_sc_hd__xnor2_1 A B VGND VNB VPB VPWR Y
.ends

* Black-box entry subcircuit for sky130_fd_sc_hd__clkbuf_4 abstract view
.subckt sky130_fd_sc_hd__clkbuf_4 A VGND VNB VPB VPWR X
.ends

* Black-box entry subcircuit for sky130_fd_sc_hd__inv_6 abstract view
.subckt sky130_fd_sc_hd__inv_6 A VGND VNB VPB VPWR Y
.ends

* Black-box entry subcircuit for sky130_fd_sc_hd__inv_8 abstract view
.subckt sky130_fd_sc_hd__inv_8 A VGND VNB VPB VPWR Y
.ends

* Black-box entry subcircuit for sky130_fd_sc_hd__o31ai_1 abstract view
.subckt sky130_fd_sc_hd__o31ai_1 A1 A2 A3 B1 VGND VNB VPB VPWR Y
.ends

* Black-box entry subcircuit for sky130_fd_sc_hd__bufinv_16 abstract view
.subckt sky130_fd_sc_hd__bufinv_16 A VGND VNB VPB VPWR Y
.ends

* Black-box entry subcircuit for sky130_fd_sc_hd__clkinv_8 abstract view
.subckt sky130_fd_sc_hd__clkinv_8 A VGND VNB VPB VPWR Y
.ends

* Black-box entry subcircuit for sky130_fd_sc_hd__a211o_1 abstract view
.subckt sky130_fd_sc_hd__a211o_1 A1 A2 B1 C1 VGND VNB VPB VPWR X
.ends

* Black-box entry subcircuit for sky130_fd_sc_hd__clkbuf_2 abstract view
.subckt sky130_fd_sc_hd__clkbuf_2 A VGND VNB VPB VPWR X
.ends

* Black-box entry subcircuit for sky130_fd_sc_hd__o21ai_1 abstract view
.subckt sky130_fd_sc_hd__o21ai_1 A1 A2 B1 VGND VNB VPB VPWR Y
.ends

* Black-box entry subcircuit for sky130_fd_sc_hd__mux4_1 abstract view
.subckt sky130_fd_sc_hd__mux4_1 A0 A1 A2 A3 S0 S1 VGND VNB VPB VPWR X
.ends

* Black-box entry subcircuit for sky130_fd_sc_hd__clkinv_2 abstract view
.subckt sky130_fd_sc_hd__clkinv_2 A VGND VNB VPB VPWR Y
.ends

* Black-box entry subcircuit for sky130_fd_sc_hd__nor2_2 abstract view
.subckt sky130_fd_sc_hd__nor2_2 A B VGND VNB VPB VPWR Y
.ends

* Black-box entry subcircuit for sky130_fd_sc_hd__or3b_2 abstract view
.subckt sky130_fd_sc_hd__or3b_2 A B C_N VGND VNB VPB VPWR X
.ends

* Black-box entry subcircuit for sky130_fd_sc_hd__clkinvlp_4 abstract view
.subckt sky130_fd_sc_hd__clkinvlp_4 A VGND VNB VPB VPWR Y
.ends

* Black-box entry subcircuit for sky130_fd_sc_hd__and2b_2 abstract view
.subckt sky130_fd_sc_hd__and2b_2 A_N B VGND VNB VPB VPWR X
.ends

* Black-box entry subcircuit for sky130_fd_sc_hd__nand2_4 abstract view
.subckt sky130_fd_sc_hd__nand2_4 A B VGND VNB VPB VPWR Y
.ends

* Black-box entry subcircuit for sky130_fd_sc_hd__o21bai_1 abstract view
.subckt sky130_fd_sc_hd__o21bai_1 A1 A2 B1_N VGND VNB VPB VPWR Y
.ends

* Black-box entry subcircuit for sky130_fd_sc_hd__or3_2 abstract view
.subckt sky130_fd_sc_hd__or3_2 A B C VGND VNB VPB VPWR X
.ends

* Black-box entry subcircuit for sky130_fd_sc_hd__nor3b_1 abstract view
.subckt sky130_fd_sc_hd__nor3b_1 A B C_N VGND VNB VPB VPWR Y
.ends

* Black-box entry subcircuit for sky130_fd_sc_hd__clkinv_4 abstract view
.subckt sky130_fd_sc_hd__clkinv_4 A VGND VNB VPB VPWR Y
.ends

* Black-box entry subcircuit for sky130_fd_sc_hd__buf_1 abstract view
.subckt sky130_fd_sc_hd__buf_1 A VGND VNB VPB VPWR X
.ends

* Black-box entry subcircuit for sky130_fd_sc_hd__dfstp_1 abstract view
.subckt sky130_fd_sc_hd__dfstp_1 CLK D SET_B VGND VNB VPB VPWR Q
.ends

* Black-box entry subcircuit for sky130_fd_sc_hd__or3_1 abstract view
.subckt sky130_fd_sc_hd__or3_1 A B C VGND VNB VPB VPWR X
.ends

* Black-box entry subcircuit for sky130_fd_sc_hd__and2b_1 abstract view
.subckt sky130_fd_sc_hd__and2b_1 A_N B VGND VNB VPB VPWR X
.ends

* Black-box entry subcircuit for sky130_fd_sc_hd__a2bb2o_1 abstract view
.subckt sky130_fd_sc_hd__a2bb2o_1 A1_N A2_N B1 B2 VGND VNB VPB VPWR X
.ends

* Black-box entry subcircuit for sky130_fd_sc_hd__or4_2 abstract view
.subckt sky130_fd_sc_hd__or4_2 A B C D VGND VNB VPB VPWR X
.ends

* Black-box entry subcircuit for sky130_fd_sc_hd__and3_2 abstract view
.subckt sky130_fd_sc_hd__and3_2 A B C VGND VNB VPB VPWR X
.ends

* Black-box entry subcircuit for sky130_fd_sc_hd__and3b_2 abstract view
.subckt sky130_fd_sc_hd__and3b_2 A_N B C VGND VNB VPB VPWR X
.ends

* Black-box entry subcircuit for sky130_fd_sc_hd__a41oi_2 abstract view
.subckt sky130_fd_sc_hd__a41oi_2 A1 A2 A3 A4 B1 VGND VNB VPB VPWR Y
.ends

* Black-box entry subcircuit for sky130_fd_sc_hd__o21a_2 abstract view
.subckt sky130_fd_sc_hd__o21a_2 A1 A2 B1 VGND VNB VPB VPWR X
.ends

* Black-box entry subcircuit for sky130_fd_sc_hd__a21boi_1 abstract view
.subckt sky130_fd_sc_hd__a21boi_1 A1 A2 B1_N VGND VNB VPB VPWR Y
.ends

* Black-box entry subcircuit for sky130_fd_sc_hd__or2_4 abstract view
.subckt sky130_fd_sc_hd__or2_4 A B VGND VNB VPB VPWR X
.ends

* Black-box entry subcircuit for sky130_fd_sc_hd__or3_4 abstract view
.subckt sky130_fd_sc_hd__or3_4 A B C VGND VNB VPB VPWR X
.ends

.subckt dual_sensor_top VGND VPWR clk_10mhz i2c_scl i2c_sda led_status[0] led_status[1]
+ led_status[2] pwr_ctrl rst_n srf_echo srf_trig uart_tx_pin
XFILLER_54_269 VGND VGND VPWR VPWR sky130_fd_sc_hd__fill_2
XFILLER_39_277 VGND VGND VPWR VPWR sky130_fd_sc_hd__decap_3
XTAP_TAPCELL_ROW_43_415 VGND VPWR sky130_fd_sc_hd__tapvpwrvgnd_1
XFILLER_13_122 VPWR VGND VPWR VGND sky130_ef_sc_hd__decap_12
XTAP_TAPCELL_ROW_51_470 VGND VPWR sky130_fd_sc_hd__tapvpwrvgnd_1
XFILLER_9_137 VGND VGND VPWR VPWR sky130_fd_sc_hd__decap_4
X_1270_ u_fifo.rd_ptr\[3\] _0301_ VGND VGND VPWR VPWR _0302_ sky130_fd_sc_hd__nor2_4
XTAP_TAPCELL_ROW_8_192 VGND VPWR sky130_fd_sc_hd__tapvpwrvgnd_1
X_1606_ clknet_leaf_13_clk_10mhz _0109_ VGND VGND VPWR VPWR u_fifo.mem\[10\]\[3\]
+ sky130_fd_sc_hd__dfxtp_1
X_0985_ u_srf_ctrl.echo_counter\[15\] u_srf_ctrl.echo_counter\[11\] VGND VGND VPWR
+ VPWR _0659_ sky130_fd_sc_hd__xor2_1
X_1399_ net234 _0494_ _0407_ VGND VGND VPWR VPWR _0243_ sky130_fd_sc_hd__a21oi_1
XTAP_TAPCELL_ROW_57_507 VGND VPWR sky130_fd_sc_hd__tapvpwrvgnd_1
X_1468_ u_srf_ctrl.echo_counter\[11\] u_srf_ctrl.echo_counter\[10\] _0449_ VGND VGND
+ VPWR VPWR _0451_ sky130_fd_sc_hd__and3b_1
X_1537_ clknet_leaf_24_clk_10mhz _0062_ net25 VGND VGND VPWR VPWR u_packet_assembler.timer\[17\]
+ sky130_fd_sc_hd__dfrtp_1
XFILLER_27_258 VGND VGND VPWR VPWR sky130_fd_sc_hd__decap_4
XPHY_EDGE_ROW_19_Left_83 VGND VGND VPWR VPWR sky130_fd_sc_hd__decap_3
XFILLER_6_107 VGND VGND VPWR VPWR sky130_fd_sc_hd__decap_8
Xhold170 u_fifo.wr_ptr\[4\] VGND VGND VPWR VPWR net238 sky130_fd_sc_hd__dlygate4sd3_1
XFILLER_2_357 VGND VGND VPWR VPWR sky130_fd_sc_hd__decap_6
Xhold192 u_packet_assembler.timer\[6\] VGND VGND VPWR VPWR net260 sky130_fd_sc_hd__dlygate4sd3_1
Xhold181 u_max30102_ctrl.clk_div\[8\] VGND VGND VPWR VPWR net249 sky130_fd_sc_hd__dlygate4sd3_1
XFILLER_12_76 VGND VGND VPWR VPWR sky130_fd_sc_hd__decap_8
XFILLER_18_269 VPWR VGND VPWR VGND sky130_ef_sc_hd__decap_12
X_0770_ net32 u_fifo.wr_ptr\[2\] VGND VGND VPWR VPWR _0487_ sky130_fd_sc_hd__xor2_1
X_1322_ u_fifo.mem\[4\]\[3\] _0311_ _0346_ _0348_ _0350_ VGND VGND VPWR VPWR _0351_
+ sky130_fd_sc_hd__a2111o_1
X_1253_ _0286_ _0291_ VGND VGND VPWR VPWR _0292_ sky130_fd_sc_hd__nand2_1
Xclkbuf_leaf_9_clk_10mhz clknet_2_1__leaf_clk_10mhz VGND VGND VPWR VPWR clknet_leaf_9_clk_10mhz
+ sky130_fd_sc_hd__clkbuf_8
X_1184_ net140 net44 _0743_ VGND VGND VPWR VPWR _0157_ sky130_fd_sc_hd__mux2_1
XTAP_TAPCELL_ROW_62_543 VGND VPWR sky130_fd_sc_hd__tapvpwrvgnd_1
X_0968_ _0604_ _0641_ VGND VGND VPWR VPWR _0642_ sky130_fd_sc_hd__nand2_1
X_0899_ _0468_ _0577_ _0581_ VGND VGND VPWR VPWR _0034_ sky130_fd_sc_hd__a21oi_1
XPHY_EDGE_ROW_4_Left_68 VGND VGND VPWR VPWR sky130_fd_sc_hd__decap_3
XFILLER_23_97 VGND VGND VPWR VPWR sky130_fd_sc_hd__decap_6
XFILLER_2_121 VPWR VGND VPWR VGND sky130_ef_sc_hd__decap_12
XFILLER_61_301 VPWR VGND VPWR VGND sky130_ef_sc_hd__decap_12
XFILLER_0_57 VPWR VGND VPWR VGND sky130_ef_sc_hd__decap_12
X_0822_ u_max30102_ctrl.clk_div\[4\] _0527_ VGND VGND VPWR VPWR _0530_ sky130_fd_sc_hd__nand2_1
XFILLER_14_250 VGND VGND VPWR VPWR sky130_fd_sc_hd__fill_2
X_0753_ u_uart.bit_index\[2\] VGND VGND VPWR VPWR _0472_ sky130_fd_sc_hd__inv_2
XFILLER_50_3 VPWR VGND VPWR VGND sky130_ef_sc_hd__decap_12
X_1305_ u_fifo.mem\[12\]\[2\] _0298_ _0307_ u_fifo.mem\[10\]\[2\] VGND VGND VPWR VPWR
+ _0335_ sky130_fd_sc_hd__a22o_1
X_1236_ net118 net50 _0285_ VGND VGND VPWR VPWR _0202_ sky130_fd_sc_hd__mux2_1
XFILLER_52_323 VGND VGND VPWR VPWR sky130_fd_sc_hd__decap_3
X_1167_ net173 net43 _0741_ VGND VGND VPWR VPWR _0142_ sky130_fd_sc_hd__mux2_1
X_1098_ distance_out\[4\] _0546_ VGND VGND VPWR VPWR _0725_ sky130_fd_sc_hd__or2_1
XFILLER_60_29 VPWR VGND VPWR VGND sky130_ef_sc_hd__decap_12
XFILLER_60_18 VGND VGND VPWR VPWR sky130_fd_sc_hd__decap_8
XFILLER_20_253 VGND VGND VPWR VPWR sky130_fd_sc_hd__fill_2
XFILLER_20_275 VPWR VGND VPWR VGND sky130_ef_sc_hd__decap_12
XTAP_TAPCELL_ROW_38_381 VGND VPWR sky130_fd_sc_hd__tapvpwrvgnd_1
XFILLER_11_242 VGND VGND VPWR VPWR sky130_fd_sc_hd__decap_8
XFILLER_38_128 VPWR VGND VPWR VGND sky130_ef_sc_hd__decap_12
X_1021_ u_packet_assembler.timer\[7\] _0683_ VGND VGND VPWR VPWR _0686_ sky130_fd_sc_hd__nand2_1
X_0805_ _0516_ u_srf_ctrl.state\[2\] VGND VGND VPWR VPWR _0518_ sky130_fd_sc_hd__nand2b_1
X_1219_ net116 net48 _0283_ VGND VGND VPWR VPWR _0187_ sky130_fd_sc_hd__mux2_1
XFILLER_52_197 VGND VGND VPWR VPWR sky130_fd_sc_hd__decap_4
XTAP_TAPCELL_ROW_35_362 VGND VPWR sky130_fd_sc_hd__tapvpwrvgnd_1
XFILLER_4_216 VGND VGND VPWR VPWR sky130_fd_sc_hd__decap_4
XFILLER_4_205 VGND VGND VPWR VPWR sky130_fd_sc_hd__decap_4
XFILLER_20_65 VGND VGND VPWR VPWR sky130_fd_sc_hd__decap_3
Xhold74 u_fifo.mem\[7\]\[0\] VGND VGND VPWR VPWR net142 sky130_fd_sc_hd__dlygate4sd3_1
Xhold63 u_fifo.mem\[7\]\[3\] VGND VGND VPWR VPWR net131 sky130_fd_sc_hd__dlygate4sd3_1
Xhold52 u_fifo.mem\[7\]\[2\] VGND VGND VPWR VPWR net120 sky130_fd_sc_hd__dlygate4sd3_1
Xhold41 u_fifo.mem\[12\]\[4\] VGND VGND VPWR VPWR net109 sky130_fd_sc_hd__dlygate4sd3_1
Xhold30 u_fifo.mem\[2\]\[3\] VGND VGND VPWR VPWR net98 sky130_fd_sc_hd__dlygate4sd3_1
Xhold85 u_fifo.mem\[8\]\[1\] VGND VGND VPWR VPWR net153 sky130_fd_sc_hd__dlygate4sd3_1
XFILLER_43_186 VGND VGND VPWR VPWR sky130_fd_sc_hd__fill_1
Xhold96 u_fifo.mem\[11\]\[2\] VGND VGND VPWR VPWR net164 sky130_fd_sc_hd__dlygate4sd3_1
XFILLER_31_337 VPWR VGND VPWR VGND sky130_ef_sc_hd__decap_12
XPHY_EDGE_ROW_7_Left_71 VGND VGND VPWR VPWR sky130_fd_sc_hd__decap_3
X_1570_ clknet_leaf_9_clk_10mhz _0078_ net64 VGND VGND VPWR VPWR u_uart.tx_data_reg\[1\]
+ sky130_fd_sc_hd__dfrtp_1
XTAP_TAPCELL_ROW_49_454 VGND VPWR sky130_fd_sc_hd__tapvpwrvgnd_1
XFILLER_13_3 VPWR VGND VPWR VGND sky130_ef_sc_hd__decap_12
XFILLER_34_197 VGND VGND VPWR VPWR sky130_fd_sc_hd__decap_6
XTAP_TAPCELL_ROW_32_343 VGND VPWR sky130_fd_sc_hd__tapvpwrvgnd_1
X_1004_ net12 _0673_ _0674_ net16 u_packet_assembler.timer\[1\] VGND VGND VPWR VPWR
+ _0046_ sky130_fd_sc_hd__a32o_1
X_1768_ clknet_leaf_27_clk_10mhz _0271_ net52 VGND VGND VPWR VPWR u_srf_ctrl.echo_counter\[13\]
+ sky130_fd_sc_hd__dfrtp_1
XFILLER_57_223 VGND VGND VPWR VPWR sky130_fd_sc_hd__fill_1
X_1699_ clknet_leaf_8_clk_10mhz _0202_ VGND VGND VPWR VPWR u_fifo.mem\[0\]\[0\] sky130_fd_sc_hd__dfxtp_1
XFILLER_57_289 VGND VGND VPWR VPWR sky130_fd_sc_hd__decap_6
XFILLER_25_120 VGND VGND VPWR VPWR sky130_fd_sc_hd__fill_1
XFILLER_25_164 VGND VGND VPWR VPWR sky130_fd_sc_hd__decap_4
XFILLER_13_337 VPWR VGND VPWR VGND sky130_ef_sc_hd__decap_12
Xclkbuf_leaf_24_clk_10mhz clknet_2_2__leaf_clk_10mhz VGND VGND VPWR VPWR clknet_leaf_24_clk_10mhz
+ sky130_fd_sc_hd__clkbuf_8
XPHY_EDGE_ROW_33_Left_97 VGND VGND VPWR VPWR sky130_fd_sc_hd__decap_3
Xoutput7 net7 VGND VGND VPWR VPWR srf_trig sky130_fd_sc_hd__buf_2
XTAP_TAPCELL_ROW_54_490 VGND VPWR sky130_fd_sc_hd__tapvpwrvgnd_1
XTAP_TAPCELL_ROW_46_435 VGND VPWR sky130_fd_sc_hd__tapvpwrvgnd_1
XFILLER_16_197 VGND VGND VPWR VPWR sky130_fd_sc_hd__decap_6
X_1622_ clknet_leaf_14_clk_10mhz _0125_ VGND VGND VPWR VPWR u_fifo.mem\[8\]\[3\] sky130_fd_sc_hd__dfxtp_1
X_1484_ _0459_ _0461_ u_uart.bit_index\[0\] VGND VGND VPWR VPWR _0462_ sky130_fd_sc_hd__o21a_1
X_1553_ clknet_leaf_21_clk_10mhz _0019_ net23 VGND VGND VPWR VPWR u_max30102_ctrl.clk_div\[8\]
+ sky130_fd_sc_hd__dfrtp_1
XFILLER_62_270 VPWR VGND VPWR VGND sky130_ef_sc_hd__decap_12
XFILLER_10_329 VGND VGND VPWR VPWR sky130_fd_sc_hd__fill_1
XFILLER_53_281 VPWR VGND VPWR VGND sky130_ef_sc_hd__decap_12
XTAP_TAPCELL_ROW_43_416 VGND VPWR sky130_fd_sc_hd__tapvpwrvgnd_1
XFILLER_26_64 VGND VGND VPWR VPWR sky130_fd_sc_hd__fill_1
XFILLER_9_105 VGND VGND VPWR VPWR sky130_fd_sc_hd__decap_6
XFILLER_13_134 VGND VGND VPWR VPWR sky130_fd_sc_hd__decap_4
XTAP_TAPCELL_ROW_51_471 VGND VPWR sky130_fd_sc_hd__tapvpwrvgnd_1
XFILLER_42_85 VGND VGND VPWR VPWR sky130_fd_sc_hd__decap_4
XFILLER_42_74 VGND VGND VPWR VPWR sky130_fd_sc_hd__decap_3
XFILLER_13_178 VPWR VGND VPWR VGND sky130_ef_sc_hd__decap_12
X_0984_ _0651_ _0652_ _0657_ _0649_ _0648_ VGND VGND VPWR VPWR _0658_ sky130_fd_sc_hd__a311o_1
X_1605_ clknet_leaf_8_clk_10mhz _0108_ VGND VGND VPWR VPWR u_fifo.mem\[10\]\[2\] sky130_fd_sc_hd__dfxtp_1
X_1536_ clknet_leaf_22_clk_10mhz _0061_ net23 VGND VGND VPWR VPWR u_packet_assembler.timer\[16\]
+ sky130_fd_sc_hd__dfrtp_1
X_1398_ _0494_ _0404_ net234 VGND VGND VPWR VPWR _0407_ sky130_fd_sc_hd__a21oi_1
XTAP_TAPCELL_ROW_57_508 VGND VPWR sky130_fd_sc_hd__tapvpwrvgnd_1
X_1467_ u_srf_ctrl.echo_counter\[10\] _0449_ _0450_ VGND VGND VPWR VPWR _0268_ sky130_fd_sc_hd__o21a_1
XFILLER_63_29 VPWR VGND VPWR VGND sky130_ef_sc_hd__decap_12
XFILLER_50_251 VGND VGND VPWR VPWR sky130_fd_sc_hd__fill_1
XFILLER_35_281 VGND VGND VPWR VPWR sky130_fd_sc_hd__decap_6
XFILLER_50_262 VGND VGND VPWR VPWR sky130_fd_sc_hd__fill_2
XFILLER_12_66 VGND VGND VPWR VPWR sky130_fd_sc_hd__decap_4
Xhold160 u_uart.tx_data_reg\[7\] VGND VGND VPWR VPWR net228 sky130_fd_sc_hd__dlygate4sd3_1
Xhold171 u_uart.tx_data_reg\[3\] VGND VGND VPWR VPWR net239 sky130_fd_sc_hd__dlygate4sd3_1
Xhold182 _0535_ VGND VGND VPWR VPWR net250 sky130_fd_sc_hd__dlygate4sd3_1
Xhold193 u_max30102_ctrl.clk_div\[12\] VGND VGND VPWR VPWR net261 sky130_fd_sc_hd__dlygate4sd3_1
XFILLER_37_63 VGND VGND VPWR VPWR sky130_fd_sc_hd__decap_8
XFILLER_26_270 VGND VGND VPWR VPWR sky130_fd_sc_hd__fill_1
X_1321_ u_fifo.mem\[1\]\[3\] _0302_ _0308_ u_fifo.mem\[5\]\[3\] _0349_ VGND VGND VPWR
+ VPWR _0350_ sky130_fd_sc_hd__a221o_1
X_1252_ net35 net33 net32 u_fifo.rd_ptr\[3\] VGND VGND VPWR VPWR _0291_ sky130_fd_sc_hd__and4_4
X_1183_ net152 net47 _0743_ VGND VGND VPWR VPWR _0156_ sky130_fd_sc_hd__mux2_1
XFILLER_17_281 VPWR VGND VPWR VGND sky130_ef_sc_hd__decap_12
XPHY_EDGE_ROW_20_Left_84 VGND VGND VPWR VPWR sky130_fd_sc_hd__decap_3
X_0967_ u_srf_ctrl.echo_counter\[13\] u_srf_ctrl.echo_counter\[9\] VGND VGND VPWR
+ VPWR _0641_ sky130_fd_sc_hd__or2_1
XFILLER_59_104 VGND VGND VPWR VPWR sky130_fd_sc_hd__fill_2
XFILLER_58_29 VGND VGND VPWR VPWR sky130_fd_sc_hd__fill_1
X_0898_ net10 _0580_ _0468_ _0555_ VGND VGND VPWR VPWR _0581_ sky130_fd_sc_hd__o2bb2a_1
XPHY_EDGE_ROW_12_Right_12 VGND VGND VPWR VPWR sky130_fd_sc_hd__decap_3
X_1519_ clknet_leaf_0_clk_10mhz net2 net54 VGND VGND VPWR VPWR u_srf_ctrl.echo_sync_0
+ sky130_fd_sc_hd__dfrtp_1
XFILLER_55_321 VPWR VGND VPWR VGND sky130_ef_sc_hd__decap_12
XFILLER_55_310 VGND VGND VPWR VPWR sky130_fd_sc_hd__fill_2
XPHY_EDGE_ROW_21_Right_21 VGND VGND VPWR VPWR sky130_fd_sc_hd__decap_3
XFILLER_23_43 VGND VGND VPWR VPWR sky130_fd_sc_hd__decap_4
XPHY_EDGE_ROW_30_Right_30 VGND VGND VPWR VPWR sky130_fd_sc_hd__decap_3
XFILLER_2_133 VGND VGND VPWR VPWR sky130_fd_sc_hd__decap_6
XFILLER_61_313 VPWR VGND VPWR VGND sky130_ef_sc_hd__decap_12
XFILLER_46_365 VPWR VGND VPWR VGND sky130_ef_sc_hd__decap_12
XFILLER_46_332 VGND VGND VPWR VPWR sky130_fd_sc_hd__fill_1
XFILLER_0_69 VPWR VGND VPWR VGND sky130_ef_sc_hd__decap_12
X_0752_ net271 VGND VGND VPWR VPWR _0471_ sky130_fd_sc_hd__inv_2
X_0821_ _0526_ _0528_ _0529_ VGND VGND VPWR VPWR _0014_ sky130_fd_sc_hd__and3_1
XTAP_TAPCELL_ROW_24_290 VGND VPWR sky130_fd_sc_hd__tapvpwrvgnd_1
XFILLER_43_3 VPWR VGND VPWR VGND sky130_ef_sc_hd__decap_12
X_1166_ net131 net44 _0741_ VGND VGND VPWR VPWR _0141_ sky130_fd_sc_hd__mux2_1
XFILLER_37_376 VGND VGND VPWR VPWR sky130_fd_sc_hd__fill_1
X_1235_ net61 _0737_ _0280_ VGND VGND VPWR VPWR _0285_ sky130_fd_sc_hd__and3_4
X_1304_ net26 u_fifo.mem\[2\]\[2\] _0303_ VGND VGND VPWR VPWR _0334_ sky130_fd_sc_hd__o21ba_1
XFILLER_52_313 VGND VGND VPWR VPWR sky130_fd_sc_hd__fill_1
X_1097_ _0546_ _0714_ _0713_ VGND VGND VPWR VPWR _0724_ sky130_fd_sc_hd__a21o_1
XFILLER_20_287 VPWR VGND VPWR VGND sky130_ef_sc_hd__decap_12
XFILLER_47_107 VGND VGND VPWR VPWR sky130_fd_sc_hd__decap_4
XFILLER_43_335 VGND VGND VPWR VPWR sky130_fd_sc_hd__fill_1
XTAP_TAPCELL_ROW_38_382 VGND VPWR sky130_fd_sc_hd__tapvpwrvgnd_1
XFILLER_28_365 VPWR VGND VPWR VGND sky130_ef_sc_hd__decap_12
XFILLER_7_214 VGND VGND VPWR VPWR sky130_fd_sc_hd__decap_8
XFILLER_7_225 VGND VGND VPWR VPWR sky130_fd_sc_hd__decap_6
XFILLER_7_236 VGND VGND VPWR VPWR sky130_fd_sc_hd__decap_4
XTAP_TAPCELL_ROW_21_271 VGND VPWR sky130_fd_sc_hd__tapvpwrvgnd_1
XFILLER_50_85 VGND VGND VPWR VPWR sky130_fd_sc_hd__decap_6
X_1020_ net13 _0684_ _0685_ net16 net260 VGND VGND VPWR VPWR _0051_ sky130_fd_sc_hd__a32o_1
XFILLER_34_302 VGND VGND VPWR VPWR sky130_fd_sc_hd__decap_6
X_0804_ u_srf_ctrl.state\[2\] _0516_ _0517_ VGND VGND VPWR VPWR _0002_ sky130_fd_sc_hd__a21bo_1
X_1149_ net86 net41 _0738_ VGND VGND VPWR VPWR _0127_ sky130_fd_sc_hd__mux2_1
XFILLER_29_129 VGND VGND VPWR VPWR sky130_fd_sc_hd__fill_2
X_1218_ net92 net51 _0283_ VGND VGND VPWR VPWR _0186_ sky130_fd_sc_hd__mux2_1
XTAP_TAPCELL_ROW_35_363 VGND VPWR sky130_fd_sc_hd__tapvpwrvgnd_1
Xhold64 u_fifo.mem\[5\]\[4\] VGND VGND VPWR VPWR net132 sky130_fd_sc_hd__dlygate4sd3_1
Xhold97 u_fifo.mem\[9\]\[4\] VGND VGND VPWR VPWR net165 sky130_fd_sc_hd__dlygate4sd3_1
Xhold75 u_fifo.mem\[5\]\[6\] VGND VGND VPWR VPWR net143 sky130_fd_sc_hd__dlygate4sd3_1
XPHY_EDGE_ROW_42_Left_106 VGND VGND VPWR VPWR sky130_fd_sc_hd__decap_3
Xhold53 u_fifo.mem\[7\]\[7\] VGND VGND VPWR VPWR net121 sky130_fd_sc_hd__dlygate4sd3_1
Xhold86 u_fifo.mem\[4\]\[2\] VGND VGND VPWR VPWR net154 sky130_fd_sc_hd__dlygate4sd3_1
Xhold42 u_fifo.mem\[3\]\[2\] VGND VGND VPWR VPWR net110 sky130_fd_sc_hd__dlygate4sd3_1
XFILLER_29_75 VGND VGND VPWR VPWR sky130_fd_sc_hd__decap_6
Xhold31 u_fifo.mem\[6\]\[3\] VGND VGND VPWR VPWR net99 sky130_fd_sc_hd__dlygate4sd3_1
Xhold20 u_fifo.mem\[2\]\[5\] VGND VGND VPWR VPWR net88 sky130_fd_sc_hd__dlygate4sd3_1
XPHY_EDGE_ROW_51_Left_115 VGND VGND VPWR VPWR sky130_fd_sc_hd__decap_3
XFILLER_31_349 VPWR VGND VPWR VGND sky130_ef_sc_hd__decap_12
XFILLER_61_73 VPWR VGND VPWR VGND sky130_ef_sc_hd__decap_12
XFILLER_61_51 VGND VGND VPWR VPWR sky130_fd_sc_hd__decap_4
XPHY_EDGE_ROW_60_Left_124 VGND VGND VPWR VPWR sky130_fd_sc_hd__decap_3
XFILLER_3_261 VGND VGND VPWR VPWR sky130_fd_sc_hd__decap_8
XTAP_TAPCELL_ROW_49_455 VGND VPWR sky130_fd_sc_hd__tapvpwrvgnd_1
X_1003_ u_packet_assembler.timer\[1\] u_packet_assembler.timer\[0\] VGND VGND VPWR
+ VPWR _0674_ sky130_fd_sc_hd__or2_1
XTAP_TAPCELL_ROW_32_344 VGND VPWR sky130_fd_sc_hd__tapvpwrvgnd_1
X_1698_ clknet_leaf_15_clk_10mhz _0201_ VGND VGND VPWR VPWR u_fifo.mem\[1\]\[7\] sky130_fd_sc_hd__dfxtp_1
XPHY_EDGE_ROW_6_Right_6 VGND VGND VPWR VPWR sky130_fd_sc_hd__decap_3
X_1767_ clknet_leaf_27_clk_10mhz _0270_ net52 VGND VGND VPWR VPWR u_srf_ctrl.echo_counter\[12\]
+ sky130_fd_sc_hd__dfrtp_1
XFILLER_57_279 VGND VGND VPWR VPWR sky130_fd_sc_hd__fill_1
XFILLER_40_124 VPWR VGND VPWR VGND sky130_ef_sc_hd__decap_12
XFILLER_13_349 VPWR VGND VPWR VGND sky130_ef_sc_hd__decap_12
XFILLER_25_176 VGND VGND VPWR VPWR sky130_fd_sc_hd__fill_1
XFILLER_40_179 VGND VGND VPWR VPWR sky130_fd_sc_hd__decap_4
XFILLER_9_309 VPWR VGND VPWR VGND sky130_ef_sc_hd__decap_12
Xclkbuf_leaf_28_clk_10mhz clknet_2_0__leaf_clk_10mhz VGND VGND VPWR VPWR clknet_leaf_28_clk_10mhz
+ sky130_fd_sc_hd__clkbuf_8
Xoutput8 net8 VGND VGND VPWR VPWR uart_tx_pin sky130_fd_sc_hd__buf_2
XFILLER_0_253 VPWR VGND VPWR VGND sky130_ef_sc_hd__decap_12
XFILLER_63_205 VGND VGND VPWR VPWR sky130_fd_sc_hd__fill_1
XFILLER_56_62 VGND VGND VPWR VPWR sky130_fd_sc_hd__decap_8
XTAP_TAPCELL_ROW_46_436 VGND VPWR sky130_fd_sc_hd__tapvpwrvgnd_1
XPHY_EDGE_ROW_59_Right_59 VGND VGND VPWR VPWR sky130_fd_sc_hd__decap_3
XTAP_TAPCELL_ROW_54_491 VGND VPWR sky130_fd_sc_hd__tapvpwrvgnd_1
XFILLER_31_102 VGND VGND VPWR VPWR sky130_fd_sc_hd__decap_8
XFILLER_16_187 VGND VGND VPWR VPWR sky130_fd_sc_hd__decap_8
X_1621_ clknet_leaf_14_clk_10mhz _0124_ VGND VGND VPWR VPWR u_fifo.mem\[8\]\[2\] sky130_fd_sc_hd__dfxtp_1
XFILLER_8_342 VPWR VGND VPWR VGND sky130_ef_sc_hd__decap_12
X_1552_ clknet_leaf_22_clk_10mhz _0018_ net23 VGND VGND VPWR VPWR u_max30102_ctrl.clk_div\[7\]
+ sky130_fd_sc_hd__dfrtp_1
X_1483_ _0404_ _0460_ VGND VGND VPWR VPWR _0461_ sky130_fd_sc_hd__nor2_1
XFILLER_62_282 VPWR VGND VPWR VGND sky130_ef_sc_hd__decap_12
XFILLER_53_293 VGND VGND VPWR VPWR sky130_fd_sc_hd__decap_3
XTAP_TAPCELL_ROW_43_417 VGND VPWR sky130_fd_sc_hd__tapvpwrvgnd_1
XFILLER_8_161 VGND VGND VPWR VPWR sky130_fd_sc_hd__fill_2
X_0983_ _0654_ _0655_ _0656_ _0653_ _0650_ VGND VGND VPWR VPWR _0657_ sky130_fd_sc_hd__o32a_1
X_1604_ clknet_leaf_8_clk_10mhz _0107_ VGND VGND VPWR VPWR u_fifo.mem\[10\]\[1\] sky130_fd_sc_hd__dfxtp_1
XFILLER_8_183 VPWR VGND VPWR VGND sky130_ef_sc_hd__decap_12
X_1535_ clknet_leaf_23_clk_10mhz _0060_ net23 VGND VGND VPWR VPWR u_packet_assembler.timer\[15\]
+ sky130_fd_sc_hd__dfrtp_1
XTAP_TAPCELL_ROW_57_509 VGND VPWR sky130_fd_sc_hd__tapvpwrvgnd_1
X_1397_ _0405_ VGND VGND VPWR VPWR _0406_ sky130_fd_sc_hd__inv_2
X_1466_ u_srf_ctrl.echo_counter\[10\] u_srf_ctrl.echo_counter\[9\] _0447_ _0550_ VGND
+ VGND VPWR VPWR _0450_ sky130_fd_sc_hd__a31oi_1
Xhold150 u_uart.clk_count\[7\] VGND VGND VPWR VPWR net218 sky130_fd_sc_hd__dlygate4sd3_1
Xhold172 u_fifo.rd_ptr\[4\] VGND VGND VPWR VPWR net240 sky130_fd_sc_hd__dlygate4sd3_1
Xhold183 u_max30102_ctrl.clk_div\[5\] VGND VGND VPWR VPWR net251 sky130_fd_sc_hd__dlygate4sd3_1
Xhold161 distance_out\[3\] VGND VGND VPWR VPWR net229 sky130_fd_sc_hd__dlygate4sd3_1
Xhold194 u_srf_ctrl.timer\[20\] VGND VGND VPWR VPWR net262 sky130_fd_sc_hd__dlygate4sd3_1
XFILLER_58_363 VGND VGND VPWR VPWR sky130_fd_sc_hd__fill_1
XFILLER_37_53 VGND VGND VPWR VPWR sky130_fd_sc_hd__decap_3
X_1320_ u_fifo.mem\[15\]\[3\] _0291_ _0312_ u_fifo.mem\[13\]\[3\] VGND VGND VPWR VPWR
+ _0349_ sky130_fd_sc_hd__a22o_1
X_1251_ _0289_ _0290_ VGND VGND VPWR VPWR _0212_ sky130_fd_sc_hd__nor2_1
X_1182_ net72 net48 _0743_ VGND VGND VPWR VPWR _0155_ sky130_fd_sc_hd__mux2_1
XFILLER_17_293 VGND VGND VPWR VPWR sky130_fd_sc_hd__decap_6
X_0897_ _0579_ VGND VGND VPWR VPWR _0580_ sky130_fd_sc_hd__inv_2
X_0966_ _0637_ _0639_ VGND VGND VPWR VPWR _0640_ sky130_fd_sc_hd__nand2_1
X_1449_ _0437_ VGND VGND VPWR VPWR _0438_ sky130_fd_sc_hd__inv_2
X_1518_ clknet_leaf_0_clk_10mhz _0044_ net55 VGND VGND VPWR VPWR net7 sky130_fd_sc_hd__dfrtp_1
XFILLER_55_333 VGND VGND VPWR VPWR sky130_fd_sc_hd__decap_3
XFILLER_23_274 VGND VGND VPWR VPWR sky130_fd_sc_hd__decap_6
XFILLER_3_3 VPWR VGND VPWR VGND sky130_ef_sc_hd__decap_12
XFILLER_58_160 VGND VGND VPWR VPWR sky130_fd_sc_hd__decap_6
XFILLER_48_85 VGND VGND VPWR VPWR sky130_fd_sc_hd__decap_4
XFILLER_48_52 VGND VGND VPWR VPWR sky130_fd_sc_hd__fill_1
XFILLER_2_178 VPWR VGND VPWR VGND sky130_ef_sc_hd__decap_12
XFILLER_0_15 VPWR VGND VPWR VGND sky130_ef_sc_hd__decap_12
XFILLER_61_325 VGND VGND VPWR VPWR sky130_fd_sc_hd__decap_8
X_0751_ u_uart.state\[0\] VGND VGND VPWR VPWR _0470_ sky130_fd_sc_hd__inv_2
X_0820_ u_max30102_ctrl.clk_div\[1\] u_max30102_ctrl.clk_div\[0\] u_max30102_ctrl.clk_div\[2\]
+ u_max30102_ctrl.clk_div\[3\] VGND VGND VPWR VPWR _0529_ sky130_fd_sc_hd__a31o_1
XTAP_TAPCELL_ROW_24_291 VGND VPWR sky130_fd_sc_hd__tapvpwrvgnd_1
X_1303_ _0333_ net178 _0296_ VGND VGND VPWR VPWR _0221_ sky130_fd_sc_hd__mux2_1
XFILLER_36_3 VGND VGND VPWR VPWR sky130_fd_sc_hd__fill_2
X_1234_ net89 net37 _0284_ VGND VGND VPWR VPWR _0201_ sky130_fd_sc_hd__mux2_1
X_1165_ net120 net46 _0741_ VGND VGND VPWR VPWR _0140_ sky130_fd_sc_hd__mux2_1
X_1096_ net45 _0021_ _0717_ _0723_ VGND VGND VPWR VPWR _0089_ sky130_fd_sc_hd__o22a_1
X_0949_ _0612_ _0617_ _0622_ VGND VGND VPWR VPWR _0623_ sky130_fd_sc_hd__or3b_1
XFILLER_20_299 VGND VGND VPWR VPWR sky130_fd_sc_hd__decap_8
XTAP_TAPCELL_ROW_38_383 VGND VPWR sky130_fd_sc_hd__tapvpwrvgnd_1
XFILLER_50_53 VGND VGND VPWR VPWR sky130_fd_sc_hd__decap_6
XFILLER_34_65 VPWR VGND VPWR VGND sky130_ef_sc_hd__decap_12
XFILLER_11_277 VGND VGND VPWR VPWR sky130_fd_sc_hd__decap_3
XTAP_TAPCELL_ROW_21_272 VGND VPWR sky130_fd_sc_hd__tapvpwrvgnd_1
XFILLER_59_51 VGND VGND VPWR VPWR sky130_fd_sc_hd__fill_1
XFILLER_46_141 VGND VGND VPWR VPWR sky130_fd_sc_hd__fill_1
XFILLER_61_111 VGND VGND VPWR VPWR sky130_fd_sc_hd__fill_1
XFILLER_34_336 VGND VGND VPWR VPWR sky130_fd_sc_hd__decap_6
Xfanout9 _0563_ VGND VGND VPWR VPWR net9 sky130_fd_sc_hd__buf_2
X_0803_ _0485_ u_srf_ctrl.state\[0\] VGND VGND VPWR VPWR _0517_ sky130_fd_sc_hd__nand2b_1
X_1783_ net67 _0745_ VGND VGND VPWR VPWR i2c_scl sky130_fd_sc_hd__ebufn_8
Xclkbuf_2_1__f_clk_10mhz clknet_0_clk_10mhz VGND VGND VPWR VPWR clknet_2_1__leaf_clk_10mhz
+ sky130_fd_sc_hd__clkbuf_16
XFILLER_52_166 VGND VGND VPWR VPWR sky130_fd_sc_hd__decap_3
X_1079_ net222 net211 net14 VGND VGND VPWR VPWR _0083_ sky130_fd_sc_hd__mux2_1
XFILLER_40_306 VGND VGND VPWR VPWR sky130_fd_sc_hd__fill_2
X_1148_ net124 net43 _0738_ VGND VGND VPWR VPWR _0126_ sky130_fd_sc_hd__mux2_1
XFILLER_37_152 VPWR VGND VPWR VGND sky130_ef_sc_hd__decap_12
XTAP_TAPCELL_ROW_35_364 VGND VPWR sky130_fd_sc_hd__tapvpwrvgnd_1
X_1217_ u_fifo.wr_ptr\[0\] u_fifo.wr_ptr\[1\] net56 net11 VGND VGND VPWR VPWR _0283_
+ sky130_fd_sc_hd__and4b_4
Xhold54 u_fifo.mem\[3\]\[0\] VGND VGND VPWR VPWR net122 sky130_fd_sc_hd__dlygate4sd3_1
Xhold76 u_fifo.mem\[3\]\[3\] VGND VGND VPWR VPWR net144 sky130_fd_sc_hd__dlygate4sd3_1
Xhold21 u_fifo.mem\[1\]\[7\] VGND VGND VPWR VPWR net89 sky130_fd_sc_hd__dlygate4sd3_1
Xhold87 u_fifo.mem\[15\]\[5\] VGND VGND VPWR VPWR net155 sky130_fd_sc_hd__dlygate4sd3_1
Xhold98 u_fifo.mem\[15\]\[2\] VGND VGND VPWR VPWR net166 sky130_fd_sc_hd__dlygate4sd3_1
Xhold65 u_fifo.mem\[3\]\[1\] VGND VGND VPWR VPWR net133 sky130_fd_sc_hd__dlygate4sd3_1
Xhold32 u_fifo.mem\[1\]\[0\] VGND VGND VPWR VPWR net100 sky130_fd_sc_hd__dlygate4sd3_1
Xhold10 u_fifo.mem\[14\]\[1\] VGND VGND VPWR VPWR net78 sky130_fd_sc_hd__dlygate4sd3_1
XFILLER_28_141 VPWR VGND VPWR VGND sky130_ef_sc_hd__decap_12
Xhold43 u_fifo.mem\[6\]\[7\] VGND VGND VPWR VPWR net111 sky130_fd_sc_hd__dlygate4sd3_1
XFILLER_61_85 VGND VGND VPWR VPWR sky130_fd_sc_hd__fill_2
XTAP_TAPCELL_ROW_49_456 VGND VPWR sky130_fd_sc_hd__tapvpwrvgnd_1
XFILLER_34_111 VGND VGND VPWR VPWR sky130_fd_sc_hd__fill_1
X_1002_ u_packet_assembler.timer\[1\] u_packet_assembler.timer\[0\] VGND VGND VPWR
+ VPWR _0673_ sky130_fd_sc_hd__nand2_1
XTAP_TAPCELL_ROW_32_345 VGND VPWR sky130_fd_sc_hd__tapvpwrvgnd_1
X_1697_ clknet_leaf_10_clk_10mhz _0200_ VGND VGND VPWR VPWR u_fifo.mem\[1\]\[6\] sky130_fd_sc_hd__dfxtp_1
X_1766_ clknet_leaf_27_clk_10mhz _0269_ net52 VGND VGND VPWR VPWR u_srf_ctrl.echo_counter\[11\]
+ sky130_fd_sc_hd__dfrtp_4
XFILLER_40_147 VPWR VGND VPWR VGND sky130_ef_sc_hd__decap_12
XFILLER_40_136 VGND VGND VPWR VPWR sky130_fd_sc_hd__decap_4
XFILLER_25_111 VGND VGND VPWR VPWR sky130_fd_sc_hd__fill_1
XFILLER_21_361 VPWR VGND VPWR VGND sky130_ef_sc_hd__decap_12
XFILLER_0_221 VGND VGND VPWR VPWR sky130_fd_sc_hd__decap_3
XFILLER_0_265 VPWR VGND VPWR VGND sky130_ef_sc_hd__decap_12
XFILLER_56_85 VPWR VGND VPWR VGND sky130_ef_sc_hd__decap_12
XFILLER_56_74 VGND VGND VPWR VPWR sky130_fd_sc_hd__decap_8
XFILLER_56_41 VGND VGND VPWR VPWR sky130_fd_sc_hd__fill_1
XTAP_TAPCELL_ROW_46_437 VGND VPWR sky130_fd_sc_hd__tapvpwrvgnd_1
XFILLER_16_133 VGND VGND VPWR VPWR sky130_fd_sc_hd__decap_6
XFILLER_31_169 VGND VGND VPWR VPWR sky130_fd_sc_hd__decap_4
XFILLER_8_321 VGND VGND VPWR VPWR sky130_fd_sc_hd__fill_1
XFILLER_8_354 VGND VGND VPWR VPWR sky130_fd_sc_hd__decap_8
X_1482_ u_uart.bit_index\[2\] _0417_ _0418_ VGND VGND VPWR VPWR _0460_ sky130_fd_sc_hd__a21o_1
X_1620_ clknet_leaf_14_clk_10mhz _0123_ VGND VGND VPWR VPWR u_fifo.mem\[8\]\[1\] sky130_fd_sc_hd__dfxtp_1
X_1551_ clknet_leaf_22_clk_10mhz _0017_ net23 VGND VGND VPWR VPWR u_max30102_ctrl.clk_div\[6\]
+ sky130_fd_sc_hd__dfrtp_1
XFILLER_8_365 VPWR VGND VPWR VGND sky130_ef_sc_hd__decap_12
XFILLER_62_294 VPWR VGND VPWR VGND sky130_ef_sc_hd__decap_12
XFILLER_10_309 VPWR VGND VPWR VGND sky130_ef_sc_hd__decap_12
X_1749_ clknet_leaf_5_clk_10mhz _0252_ net62 VGND VGND VPWR VPWR u_uart.clk_count\[9\]
+ sky130_fd_sc_hd__dfrtp_1
XFILLER_45_206 VGND VGND VPWR VPWR sky130_fd_sc_hd__decap_4
XTAP_TAPCELL_ROW_43_418 VGND VPWR sky130_fd_sc_hd__tapvpwrvgnd_1
XFILLER_42_54 VPWR VGND VPWR VGND sky130_ef_sc_hd__decap_12
XFILLER_42_43 VGND VGND VPWR VPWR sky130_fd_sc_hd__fill_1
XFILLER_26_99 VGND VGND VPWR VPWR sky130_fd_sc_hd__fill_1
XFILLER_3_15 VPWR VGND VPWR VGND sky130_ef_sc_hd__decap_12
XFILLER_44_294 VGND VGND VPWR VPWR sky130_fd_sc_hd__decap_6
Xclkbuf_leaf_10_clk_10mhz clknet_2_3__leaf_clk_10mhz VGND VGND VPWR VPWR clknet_leaf_10_clk_10mhz
+ sky130_fd_sc_hd__clkbuf_8
XFILLER_8_195 VGND VGND VPWR VPWR sky130_fd_sc_hd__fill_1
X_0982_ _0630_ _0633_ _0628_ VGND VGND VPWR VPWR _0656_ sky130_fd_sc_hd__a21oi_1
X_1603_ clknet_leaf_8_clk_10mhz _0106_ VGND VGND VPWR VPWR u_fifo.mem\[10\]\[0\] sky130_fd_sc_hd__dfxtp_1
X_1465_ _0550_ _0448_ _0449_ VGND VGND VPWR VPWR _0267_ sky130_fd_sc_hd__nor3_1
X_1534_ clknet_leaf_23_clk_10mhz _0059_ net20 VGND VGND VPWR VPWR u_packet_assembler.timer\[14\]
+ sky130_fd_sc_hd__dfrtp_1
X_1396_ _0493_ _0404_ VGND VGND VPWR VPWR _0405_ sky130_fd_sc_hd__or2_1
XFILLER_35_261 VGND VGND VPWR VPWR sky130_fd_sc_hd__fill_1
Xhold162 u_uart.clk_count\[12\] VGND VGND VPWR VPWR net230 sky130_fd_sc_hd__dlygate4sd3_1
Xhold140 u_fifo.mem\[11\]\[6\] VGND VGND VPWR VPWR net208 sky130_fd_sc_hd__dlygate4sd3_1
XFILLER_12_46 VGND VGND VPWR VPWR sky130_fd_sc_hd__fill_1
Xhold151 u_packet_assembler.timer\[19\] VGND VGND VPWR VPWR net219 sky130_fd_sc_hd__dlygate4sd3_1
Xhold195 u_packet_assembler.timer\[11\] VGND VGND VPWR VPWR net263 sky130_fd_sc_hd__dlygate4sd3_1
Xhold184 u_max30102_ctrl.scl_internal VGND VGND VPWR VPWR net252 sky130_fd_sc_hd__dlygate4sd3_1
Xhold173 distance_out\[2\] VGND VGND VPWR VPWR net241 sky130_fd_sc_hd__dlygate4sd3_1
XFILLER_53_53 VGND VGND VPWR VPWR sky130_fd_sc_hd__decap_3
XFILLER_41_220 VGND VGND VPWR VPWR sky130_fd_sc_hd__decap_4
XFILLER_18_217 VGND VGND VPWR VPWR sky130_fd_sc_hd__decap_3
X_1181_ net183 net50 _0743_ VGND VGND VPWR VPWR _0154_ sky130_fd_sc_hd__mux2_1
XFILLER_49_353 VPWR VGND VPWR VGND sky130_ef_sc_hd__decap_12
X_1250_ net33 _0287_ net32 VGND VGND VPWR VPWR _0290_ sky130_fd_sc_hd__a21oi_1
XFILLER_17_272 VGND VGND VPWR VPWR sky130_fd_sc_hd__decap_8
X_0896_ u_srf_ctrl.timer\[12\] u_srf_ctrl.timer\[11\] u_srf_ctrl.timer\[10\] _0573_
+ VGND VGND VPWR VPWR _0579_ sky130_fd_sc_hd__and4_2
X_0965_ u_srf_ctrl.echo_counter\[11\] net27 _0495_ _0636_ VGND VGND VPWR VPWR _0639_
+ sky130_fd_sc_hd__a22o_1
X_1517_ clknet_leaf_26_clk_10mhz _0043_ net53 VGND VGND VPWR VPWR u_pmu.user_detected
+ sky130_fd_sc_hd__dfrtp_1
X_1448_ u_srf_ctrl.echo_counter\[5\] u_srf_ctrl.echo_counter\[4\] net28 _0429_ VGND
+ VGND VPWR VPWR _0437_ sky130_fd_sc_hd__and4_1
X_1379_ u_srf_ctrl.state\[3\] net236 VGND VGND VPWR VPWR _0395_ sky130_fd_sc_hd__nor2_1
XFILLER_48_42 VGND VGND VPWR VPWR sky130_fd_sc_hd__decap_4
XFILLER_0_27 VGND VGND VPWR VPWR sky130_fd_sc_hd__fill_1
XFILLER_61_337 VPWR VGND VPWR VGND sky130_ef_sc_hd__decap_12
XFILLER_14_297 VGND VGND VPWR VPWR sky130_fd_sc_hd__decap_3
X_0750_ u_srf_ctrl.state\[3\] VGND VGND VPWR VPWR _0469_ sky130_fd_sc_hd__inv_2
XTAP_TAPCELL_ROW_24_292 VGND VPWR sky130_fd_sc_hd__tapvpwrvgnd_1
X_1302_ u_fifo.mem\[0\]\[1\] _0322_ _0326_ _0332_ VGND VGND VPWR VPWR _0333_ sky130_fd_sc_hd__o22a_1
X_1233_ net134 net38 _0284_ VGND VGND VPWR VPWR _0200_ sky130_fd_sc_hd__mux2_1
XFILLER_29_3 VPWR VGND VPWR VGND sky130_ef_sc_hd__decap_12
XFILLER_52_304 VGND VGND VPWR VPWR sky130_fd_sc_hd__decap_4
X_1164_ net127 net48 _0741_ VGND VGND VPWR VPWR _0139_ sky130_fd_sc_hd__mux2_1
X_1095_ distance_out\[3\] _0713_ VGND VGND VPWR VPWR _0723_ sky130_fd_sc_hd__and2_1
X_0948_ _0619_ _0620_ _0621_ _0608_ VGND VGND VPWR VPWR _0622_ sky130_fd_sc_hd__o211a_1
X_0879_ _0567_ VGND VGND VPWR VPWR _0568_ sky130_fd_sc_hd__inv_2
XFILLER_55_131 VGND VGND VPWR VPWR sky130_fd_sc_hd__decap_3
XFILLER_28_334 VPWR VGND VPWR VGND sky130_ef_sc_hd__decap_12
XFILLER_18_45 VGND VGND VPWR VPWR sky130_fd_sc_hd__fill_1
XFILLER_51_370 VGND VGND VPWR VPWR sky130_fd_sc_hd__decap_6
XFILLER_43_337 VPWR VGND VPWR VGND sky130_ef_sc_hd__decap_12
XTAP_TAPCELL_ROW_38_384 VGND VPWR sky130_fd_sc_hd__tapvpwrvgnd_1
XFILLER_11_212 VPWR VGND VPWR VGND sky130_ef_sc_hd__decap_12
XFILLER_18_89 VGND VGND VPWR VPWR sky130_fd_sc_hd__fill_1
XTAP_TAPCELL_ROW_21_273 VGND VPWR sky130_fd_sc_hd__tapvpwrvgnd_1
XFILLER_46_197 VGND VGND VPWR VPWR sky130_fd_sc_hd__decap_8
X_0802_ _0509_ _0513_ _0515_ VGND VGND VPWR VPWR _0516_ sky130_fd_sc_hd__and3_1
X_1782_ net66 net68 VGND VGND VPWR VPWR i2c_sda sky130_fd_sc_hd__ebufn_8
X_1216_ net85 net36 _0282_ VGND VGND VPWR VPWR _0185_ sky130_fd_sc_hd__mux2_1
XFILLER_37_120 VGND VGND VPWR VPWR sky130_fd_sc_hd__decap_4
X_1078_ net207 net162 net14 VGND VGND VPWR VPWR _0082_ sky130_fd_sc_hd__mux2_1
XFILLER_52_134 VGND VGND VPWR VPWR sky130_fd_sc_hd__decap_6
XFILLER_52_123 VGND VGND VPWR VPWR sky130_fd_sc_hd__decap_3
X_1147_ net102 net44 _0738_ VGND VGND VPWR VPWR _0125_ sky130_fd_sc_hd__mux2_1
XFILLER_37_164 VGND VGND VPWR VPWR sky130_fd_sc_hd__decap_4
XTAP_TAPCELL_ROW_35_365 VGND VPWR sky130_fd_sc_hd__tapvpwrvgnd_1
XFILLER_1_81 VPWR VGND VPWR VGND sky130_ef_sc_hd__decap_12
XFILLER_25_348 VPWR VGND VPWR VGND sky130_ef_sc_hd__decap_12
XFILLER_20_24 VGND VGND VPWR VPWR sky130_fd_sc_hd__fill_1
Xhold11 u_fifo.mem\[0\]\[4\] VGND VGND VPWR VPWR net79 sky130_fd_sc_hd__dlygate4sd3_1
Xhold22 u_fifo.mem\[7\]\[6\] VGND VGND VPWR VPWR net90 sky130_fd_sc_hd__dlygate4sd3_1
Xhold99 u_fifo.mem\[13\]\[4\] VGND VGND VPWR VPWR net167 sky130_fd_sc_hd__dlygate4sd3_1
Xhold44 u_fifo.mem\[12\]\[0\] VGND VGND VPWR VPWR net112 sky130_fd_sc_hd__dlygate4sd3_1
Xhold77 u_fifo.mem\[4\]\[1\] VGND VGND VPWR VPWR net145 sky130_fd_sc_hd__dlygate4sd3_1
Xhold88 u_fifo.mem\[9\]\[6\] VGND VGND VPWR VPWR net156 sky130_fd_sc_hd__dlygate4sd3_1
XFILLER_45_54 VGND VGND VPWR VPWR sky130_fd_sc_hd__fill_2
Xhold66 u_fifo.mem\[1\]\[6\] VGND VGND VPWR VPWR net134 sky130_fd_sc_hd__dlygate4sd3_1
Xhold33 u_fifo.mem\[10\]\[6\] VGND VGND VPWR VPWR net101 sky130_fd_sc_hd__dlygate4sd3_1
Xhold55 u_fifo.mem\[6\]\[1\] VGND VGND VPWR VPWR net123 sky130_fd_sc_hd__dlygate4sd3_1
XFILLER_29_55 VGND VGND VPWR VPWR sky130_fd_sc_hd__fill_1
XFILLER_28_153 VPWR VGND VPWR VGND sky130_ef_sc_hd__decap_12
XFILLER_16_337 VPWR VGND VPWR VGND sky130_ef_sc_hd__decap_12
XFILLER_43_178 VGND VGND VPWR VPWR sky130_fd_sc_hd__decap_8
XFILLER_43_156 VPWR VGND VPWR VGND sky130_ef_sc_hd__decap_12
XFILLER_6_15 VPWR VGND VPWR VGND sky130_ef_sc_hd__decap_12
XTAP_TAPCELL_ROW_49_457 VGND VPWR sky130_fd_sc_hd__tapvpwrvgnd_1
X_1001_ net12 net16 u_packet_assembler.timer\[0\] VGND VGND VPWR VPWR _0045_ sky130_fd_sc_hd__mux2_1
XFILLER_19_164 VGND VGND VPWR VPWR sky130_fd_sc_hd__decap_4
XFILLER_19_175 VPWR VGND VPWR VGND sky130_ef_sc_hd__decap_12
XFILLER_22_307 VGND VGND VPWR VPWR sky130_fd_sc_hd__fill_1
XTAP_TAPCELL_ROW_32_346 VGND VPWR sky130_fd_sc_hd__tapvpwrvgnd_1
XFILLER_30_351 VPWR VGND VPWR VGND sky130_ef_sc_hd__decap_12
X_1765_ clknet_leaf_27_clk_10mhz _0268_ net52 VGND VGND VPWR VPWR u_srf_ctrl.echo_counter\[10\]
+ sky130_fd_sc_hd__dfrtp_4
X_1696_ clknet_leaf_17_clk_10mhz _0199_ VGND VGND VPWR VPWR u_fifo.mem\[1\]\[5\] sky130_fd_sc_hd__dfxtp_1
XFILLER_40_159 VGND VGND VPWR VPWR sky130_fd_sc_hd__fill_1
XFILLER_21_373 VGND VGND VPWR VPWR sky130_fd_sc_hd__decap_4
XFILLER_48_248 VGND VGND VPWR VPWR sky130_fd_sc_hd__decap_4
XFILLER_48_215 VGND VGND VPWR VPWR sky130_fd_sc_hd__fill_1
XFILLER_0_277 VGND VGND VPWR VPWR sky130_fd_sc_hd__decap_3
XFILLER_56_97 VGND VGND VPWR VPWR sky130_fd_sc_hd__fill_1
XTAP_TAPCELL_ROW_46_438 VGND VPWR sky130_fd_sc_hd__tapvpwrvgnd_1
XFILLER_16_123 VGND VGND VPWR VPWR sky130_fd_sc_hd__decap_6
XFILLER_16_145 VGND VGND VPWR VPWR sky130_fd_sc_hd__fill_1
XFILLER_16_167 VPWR VGND VPWR VGND sky130_ef_sc_hd__decap_12
X_1481_ _0404_ _0420_ VGND VGND VPWR VPWR _0459_ sky130_fd_sc_hd__nor2_1
X_1550_ clknet_leaf_21_clk_10mhz _0016_ net23 VGND VGND VPWR VPWR u_max30102_ctrl.clk_div\[5\]
+ sky130_fd_sc_hd__dfrtp_1
XFILLER_11_3 VGND VGND VPWR VPWR sky130_fd_sc_hd__decap_8
X_1748_ clknet_leaf_5_clk_10mhz _0251_ net62 VGND VGND VPWR VPWR u_uart.clk_count\[8\]
+ sky130_fd_sc_hd__dfrtp_1
X_1679_ clknet_leaf_16_clk_10mhz _0182_ VGND VGND VPWR VPWR u_fifo.mem\[12\]\[4\]
+ sky130_fd_sc_hd__dfxtp_1
XFILLER_53_251 VGND VGND VPWR VPWR sky130_fd_sc_hd__decap_3
XTAP_TAPCELL_ROW_43_419 VGND VPWR sky130_fd_sc_hd__tapvpwrvgnd_1
XFILLER_13_104 VGND VGND VPWR VPWR sky130_fd_sc_hd__decap_8
XFILLER_26_23 VGND VGND VPWR VPWR sky130_fd_sc_hd__decap_4
XFILLER_42_66 VGND VGND VPWR VPWR sky130_fd_sc_hd__decap_8
XPHY_EDGE_ROW_39_Left_103 VGND VGND VPWR VPWR sky130_fd_sc_hd__decap_3
XFILLER_3_27 VPWR VGND VPWR VGND sky130_ef_sc_hd__decap_12
XPHY_EDGE_ROW_48_Left_112 VGND VGND VPWR VPWR sky130_fd_sc_hd__decap_3
XFILLER_44_262 VGND VGND VPWR VPWR sky130_fd_sc_hd__fill_1
XFILLER_44_251 VGND VGND VPWR VPWR sky130_fd_sc_hd__fill_1
X_0981_ _0628_ _0630_ _0633_ VGND VGND VPWR VPWR _0655_ sky130_fd_sc_hd__and3_1
XFILLER_59_3 VGND VGND VPWR VPWR sky130_fd_sc_hd__decap_6
XPHY_EDGE_ROW_57_Left_121 VGND VGND VPWR VPWR sky130_fd_sc_hd__decap_3
X_1602_ clknet_leaf_14_clk_10mhz _0105_ VGND VGND VPWR VPWR u_fifo.mem\[11\]\[7\]
+ sky130_fd_sc_hd__dfxtp_1
XFILLER_8_141 VPWR VGND VPWR VGND sky130_ef_sc_hd__decap_12
X_1395_ u_uart.clk_count\[6\] _0401_ _0403_ VGND VGND VPWR VPWR _0404_ sky130_fd_sc_hd__a21oi_2
Xclkbuf_leaf_14_clk_10mhz clknet_2_3__leaf_clk_10mhz VGND VGND VPWR VPWR clknet_leaf_14_clk_10mhz
+ sky130_fd_sc_hd__clkbuf_8
X_1464_ u_srf_ctrl.echo_counter\[9\] u_srf_ctrl.echo_counter\[8\] _0444_ VGND VGND
+ VPWR VPWR _0449_ sky130_fd_sc_hd__and3_1
X_1533_ clknet_leaf_24_clk_10mhz _0058_ net21 VGND VGND VPWR VPWR u_packet_assembler.timer\[13\]
+ sky130_fd_sc_hd__dfrtp_1
Xhold163 u_uart.tx_data_reg\[4\] VGND VGND VPWR VPWR net231 sky130_fd_sc_hd__dlygate4sd3_1
Xhold185 u_uart.clk_count\[3\] VGND VGND VPWR VPWR net253 sky130_fd_sc_hd__dlygate4sd3_1
Xhold152 u_uart.tx_data_reg\[0\] VGND VGND VPWR VPWR net220 sky130_fd_sc_hd__dlygate4sd3_1
Xhold130 u_fifo.mem\[3\]\[5\] VGND VGND VPWR VPWR net198 sky130_fd_sc_hd__dlygate4sd3_1
Xhold174 u_packet_assembler.timer\[16\] VGND VGND VPWR VPWR net242 sky130_fd_sc_hd__dlygate4sd3_1
Xhold141 u_packet_assembler.timer\[22\] VGND VGND VPWR VPWR net209 sky130_fd_sc_hd__dlygate4sd3_1
XFILLER_58_365 VPWR VGND VPWR VGND sky130_ef_sc_hd__decap_12
XTAP_TAPCELL_ROW_56_500 VGND VPWR sky130_fd_sc_hd__tapvpwrvgnd_1
XFILLER_37_44 VGND VGND VPWR VPWR sky130_fd_sc_hd__fill_2
XFILLER_37_22 VGND VGND VPWR VPWR sky130_fd_sc_hd__decap_6
XFILLER_37_11 VGND VGND VPWR VPWR sky130_fd_sc_hd__decap_3
Xhold196 u_srf_ctrl.state\[0\] VGND VGND VPWR VPWR net264 sky130_fd_sc_hd__dlygate4sd3_1
XFILLER_41_265 VGND VGND VPWR VPWR sky130_fd_sc_hd__decap_4
XFILLER_5_111 VGND VGND VPWR VPWR sky130_fd_sc_hd__fill_1
XFILLER_5_100 VGND VGND VPWR VPWR sky130_fd_sc_hd__decap_4
XFILLER_1_361 VPWR VGND VPWR VGND sky130_ef_sc_hd__decap_12
XFILLER_49_365 VPWR VGND VPWR VGND sky130_ef_sc_hd__decap_12
X_1180_ net29 net60 _0740_ net30 VGND VGND VPWR VPWR _0743_ sky130_fd_sc_hd__and4b_4
X_0964_ _0637_ VGND VGND VPWR VPWR _0638_ sky130_fd_sc_hd__inv_2
X_0895_ net10 _0577_ _0578_ _0554_ u_srf_ctrl.timer\[11\] VGND VGND VPWR VPWR _0033_
+ sky130_fd_sc_hd__a32o_1
X_1516_ clknet_leaf_0_clk_10mhz _0042_ net55 VGND VGND VPWR VPWR u_srf_ctrl.timer\[20\]
+ sky130_fd_sc_hd__dfrtp_1
X_1378_ net36 net194 _0394_ VGND VGND VPWR VPWR _0235_ sky130_fd_sc_hd__mux2_1
XTAP_TAPCELL_ROW_2_147 VGND VPWR sky130_fd_sc_hd__tapvpwrvgnd_1
X_1447_ u_srf_ctrl.echo_counter\[4\] net28 _0429_ u_srf_ctrl.echo_counter\[5\] VGND
+ VGND VPWR VPWR _0436_ sky130_fd_sc_hd__a31o_1
XFILLER_61_349 VPWR VGND VPWR VGND sky130_ef_sc_hd__decap_12
XFILLER_9_15 VPWR VGND VPWR VGND sky130_ef_sc_hd__decap_12
XFILLER_9_48 VGND VGND VPWR VPWR sky130_fd_sc_hd__decap_8
XTAP_TAPCELL_ROW_16_238 VGND VPWR sky130_fd_sc_hd__tapvpwrvgnd_1
XTAP_TAPCELL_ROW_24_293 VGND VPWR sky130_fd_sc_hd__tapvpwrvgnd_1
XPHY_EDGE_ROW_24_Left_88 VGND VGND VPWR VPWR sky130_fd_sc_hd__decap_3
XFILLER_49_140 VGND VGND VPWR VPWR sky130_fd_sc_hd__fill_2
X_1301_ u_fifo.mem\[9\]\[1\] _0309_ _0328_ _0329_ _0331_ VGND VGND VPWR VPWR _0332_
+ sky130_fd_sc_hd__a2111o_1
X_1232_ net105 net40 _0284_ VGND VGND VPWR VPWR _0199_ sky130_fd_sc_hd__mux2_1
X_1163_ net142 net50 _0741_ VGND VGND VPWR VPWR _0138_ sky130_fd_sc_hd__mux2_1
XFILLER_37_346 VPWR VGND VPWR VGND sky130_ef_sc_hd__decap_12
X_1094_ net47 _0722_ _0021_ VGND VGND VPWR VPWR _0088_ sky130_fd_sc_hd__mux2_1
X_0947_ net27 u_srf_ctrl.echo_counter\[3\] u_srf_ctrl.echo_counter\[2\] u_srf_ctrl.echo_counter\[6\]
+ VGND VGND VPWR VPWR _0621_ sky130_fd_sc_hd__o22a_1
X_0878_ u_srf_ctrl.timer\[6\] u_srf_ctrl.timer\[5\] u_srf_ctrl.timer\[4\] _0561_ VGND
+ VGND VPWR VPWR _0567_ sky130_fd_sc_hd__and4_1
XFILLER_55_143 VPWR VGND VPWR VGND sky130_ef_sc_hd__decap_12
XFILLER_28_346 VPWR VGND VPWR VGND sky130_ef_sc_hd__decap_12
XFILLER_43_349 VPWR VGND VPWR VGND sky130_ef_sc_hd__decap_12
XTAP_TAPCELL_ROW_38_385 VGND VPWR sky130_fd_sc_hd__tapvpwrvgnd_1
XFILLER_34_56 VGND VGND VPWR VPWR sky130_fd_sc_hd__decap_3
XFILLER_34_23 VGND VGND VPWR VPWR sky130_fd_sc_hd__decap_4
XTAP_TAPCELL_ROW_13_219 VGND VPWR sky130_fd_sc_hd__tapvpwrvgnd_1
XFILLER_7_206 VGND VGND VPWR VPWR sky130_fd_sc_hd__fill_1
XTAP_TAPCELL_ROW_21_274 VGND VPWR sky130_fd_sc_hd__tapvpwrvgnd_1
Xclkload0 clknet_2_0__leaf_clk_10mhz VGND VGND VPWR VPWR clkload0/X sky130_fd_sc_hd__clkbuf_8
XFILLER_59_20 VGND VGND VPWR VPWR sky130_fd_sc_hd__fill_1
XFILLER_46_121 VGND VGND VPWR VPWR sky130_fd_sc_hd__fill_2
XFILLER_19_335 VGND VGND VPWR VPWR sky130_fd_sc_hd__fill_1
X_0801_ _0481_ _0514_ VGND VGND VPWR VPWR _0515_ sky130_fd_sc_hd__nor2_1
X_1781_ u_pmu.user_detected VGND VGND VPWR VPWR net5 sky130_fd_sc_hd__clkbuf_1
XFILLER_41_3 VGND VGND VPWR VPWR sky130_fd_sc_hd__decap_3
X_1215_ net87 net38 _0282_ VGND VGND VPWR VPWR _0184_ sky130_fd_sc_hd__mux2_1
X_1146_ net128 net46 _0738_ VGND VGND VPWR VPWR _0124_ sky130_fd_sc_hd__mux2_1
X_1077_ net231 net224 net14 VGND VGND VPWR VPWR _0081_ sky130_fd_sc_hd__mux2_1
XFILLER_52_113 VGND VGND VPWR VPWR sky130_fd_sc_hd__fill_1
XTAP_TAPCELL_ROW_35_366 VGND VPWR sky130_fd_sc_hd__tapvpwrvgnd_1
XFILLER_1_93 VPWR VGND VPWR VGND sky130_ef_sc_hd__decap_12
Xhold34 u_fifo.mem\[8\]\[3\] VGND VGND VPWR VPWR net102 sky130_fd_sc_hd__dlygate4sd3_1
Xhold56 u_fifo.mem\[8\]\[4\] VGND VGND VPWR VPWR net124 sky130_fd_sc_hd__dlygate4sd3_1
Xhold23 u_fifo.mem\[10\]\[5\] VGND VGND VPWR VPWR net91 sky130_fd_sc_hd__dlygate4sd3_1
Xhold45 u_fifo.mem\[4\]\[5\] VGND VGND VPWR VPWR net113 sky130_fd_sc_hd__dlygate4sd3_1
Xhold12 u_fifo.mem\[2\]\[2\] VGND VGND VPWR VPWR net80 sky130_fd_sc_hd__dlygate4sd3_1
Xhold67 u_fifo.mem\[0\]\[2\] VGND VGND VPWR VPWR net135 sky130_fd_sc_hd__dlygate4sd3_1
Xhold78 u_fifo.mem\[4\]\[7\] VGND VGND VPWR VPWR net146 sky130_fd_sc_hd__dlygate4sd3_1
Xhold89 u_fifo.mem\[0\]\[3\] VGND VGND VPWR VPWR net157 sky130_fd_sc_hd__dlygate4sd3_1
XFILLER_43_113 VGND VGND VPWR VPWR sky130_fd_sc_hd__decap_4
XFILLER_16_349 VPWR VGND VPWR VGND sky130_ef_sc_hd__decap_12
XFILLER_61_65 VGND VGND VPWR VPWR sky130_fd_sc_hd__fill_2
XFILLER_6_27 VGND VGND VPWR VPWR sky130_fd_sc_hd__fill_1
XFILLER_10_80 VGND VGND VPWR VPWR sky130_fd_sc_hd__decap_4
XTAP_TAPCELL_ROW_49_458 VGND VPWR sky130_fd_sc_hd__tapvpwrvgnd_1
X_1000_ net17 _0669_ _0671_ VGND VGND VPWR VPWR _0672_ sky130_fd_sc_hd__nor3_1
XTAP_TAPCELL_ROW_32_347 VGND VPWR sky130_fd_sc_hd__tapvpwrvgnd_1
XFILLER_19_187 VGND VGND VPWR VPWR sky130_fd_sc_hd__decap_6
XFILLER_30_363 VGND VGND VPWR VPWR sky130_fd_sc_hd__fill_1
X_1764_ clknet_leaf_27_clk_10mhz _0267_ net52 VGND VGND VPWR VPWR u_srf_ctrl.echo_counter\[9\]
+ sky130_fd_sc_hd__dfrtp_4
X_1695_ clknet_leaf_17_clk_10mhz _0198_ VGND VGND VPWR VPWR u_fifo.mem\[1\]\[4\] sky130_fd_sc_hd__dfxtp_1
XPHY_EDGE_ROW_27_Left_91 VGND VGND VPWR VPWR sky130_fd_sc_hd__decap_3
X_1129_ net91 net40 _0734_ VGND VGND VPWR VPWR _0111_ sky130_fd_sc_hd__mux2_1
XPHY_EDGE_ROW_11_Left_75 VGND VGND VPWR VPWR sky130_fd_sc_hd__decap_3
XFILLER_13_319 VGND VGND VPWR VPWR sky130_fd_sc_hd__decap_8
XFILLER_31_57 VGND VGND VPWR VPWR sky130_fd_sc_hd__fill_1
XFILLER_56_21 VGND VGND VPWR VPWR sky130_fd_sc_hd__fill_1
XTAP_TAPCELL_ROW_46_439 VGND VPWR sky130_fd_sc_hd__tapvpwrvgnd_1
XPHY_EDGE_ROW_19_Right_19 VGND VGND VPWR VPWR sky130_fd_sc_hd__decap_3
XPHY_EDGE_ROW_28_Right_28 VGND VGND VPWR VPWR sky130_fd_sc_hd__decap_3
X_1480_ _0457_ _0458_ u_srf_ctrl.echo_counter\[15\] VGND VGND VPWR VPWR _0273_ sky130_fd_sc_hd__mux2_1
X_1783__67 VGND VGND VPWR VPWR _1783__67/HI net67 sky130_fd_sc_hd__conb_1
XPHY_EDGE_ROW_37_Right_37 VGND VGND VPWR VPWR sky130_fd_sc_hd__decap_3
XFILLER_30_171 VGND VGND VPWR VPWR sky130_fd_sc_hd__fill_1
XFILLER_22_138 VGND VGND VPWR VPWR sky130_fd_sc_hd__fill_2
X_1678_ clknet_leaf_11_clk_10mhz _0181_ VGND VGND VPWR VPWR u_fifo.mem\[12\]\[3\]
+ sky130_fd_sc_hd__dfxtp_1
XPHY_EDGE_ROW_46_Right_46 VGND VGND VPWR VPWR sky130_fd_sc_hd__decap_3
X_1747_ clknet_leaf_5_clk_10mhz _0250_ net59 VGND VGND VPWR VPWR u_uart.clk_count\[7\]
+ sky130_fd_sc_hd__dfrtp_1
XPHY_EDGE_ROW_55_Right_55 VGND VGND VPWR VPWR sky130_fd_sc_hd__decap_3
XFILLER_26_57 VGND VGND VPWR VPWR sky130_fd_sc_hd__fill_2
XFILLER_13_138 VGND VGND VPWR VPWR sky130_fd_sc_hd__fill_1
XFILLER_5_337 VPWR VGND VPWR VGND sky130_ef_sc_hd__decap_12
XFILLER_3_39 VPWR VGND VPWR VGND sky130_ef_sc_hd__decap_12
XTAP_TAPCELL_ROW_8_186 VGND VPWR sky130_fd_sc_hd__tapvpwrvgnd_1
XTAP_TAPCELL_ROW_59_520 VGND VPWR sky130_fd_sc_hd__tapvpwrvgnd_1
XFILLER_8_120 VPWR VGND VPWR VGND sky130_ef_sc_hd__decap_12
X_0980_ _0625_ _0631_ VGND VGND VPWR VPWR _0654_ sky130_fd_sc_hd__xor2_1
X_1601_ clknet_leaf_18_clk_10mhz _0104_ VGND VGND VPWR VPWR u_fifo.mem\[11\]\[6\]
+ sky130_fd_sc_hd__dfxtp_1
XFILLER_8_153 VGND VGND VPWR VPWR sky130_fd_sc_hd__decap_8
X_1532_ clknet_leaf_26_clk_10mhz _0057_ net20 VGND VGND VPWR VPWR u_packet_assembler.timer\[12\]
+ sky130_fd_sc_hd__dfrtp_1
X_1394_ u_uart.clk_count\[9\] u_uart.clk_count\[8\] u_uart.clk_count\[7\] _0402_ VGND
+ VGND VPWR VPWR _0403_ sky130_fd_sc_hd__or4_1
Xclkbuf_leaf_18_clk_10mhz clknet_2_2__leaf_clk_10mhz VGND VGND VPWR VPWR clknet_leaf_18_clk_10mhz
+ sky130_fd_sc_hd__clkbuf_8
X_1463_ u_srf_ctrl.echo_counter\[9\] _0447_ VGND VGND VPWR VPWR _0448_ sky130_fd_sc_hd__nor2_1
XFILLER_27_219 VGND VGND VPWR VPWR sky130_fd_sc_hd__decap_4
XFILLER_12_26 VGND VGND VPWR VPWR sky130_fd_sc_hd__fill_2
Xhold131 u_fifo.mem\[13\]\[2\] VGND VGND VPWR VPWR net199 sky130_fd_sc_hd__dlygate4sd3_1
Xhold120 u_fifo.mem\[11\]\[3\] VGND VGND VPWR VPWR net188 sky130_fd_sc_hd__dlygate4sd3_1
Xhold164 u_uart.clk_count\[9\] VGND VGND VPWR VPWR net232 sky130_fd_sc_hd__dlygate4sd3_1
Xhold197 u_packet_assembler.timer\[4\] VGND VGND VPWR VPWR net265 sky130_fd_sc_hd__dlygate4sd3_1
XFILLER_2_307 VGND VGND VPWR VPWR sky130_fd_sc_hd__fill_1
Xhold186 u_max30102_ctrl.clk_div\[2\] VGND VGND VPWR VPWR net254 sky130_fd_sc_hd__dlygate4sd3_1
Xhold175 u_max30102_ctrl.clk_div\[14\] VGND VGND VPWR VPWR net243 sky130_fd_sc_hd__dlygate4sd3_1
Xhold142 u_packet_assembler.timer\[18\] VGND VGND VPWR VPWR net210 sky130_fd_sc_hd__dlygate4sd3_1
Xhold153 u_packet_assembler.timer\[21\] VGND VGND VPWR VPWR net221 sky130_fd_sc_hd__dlygate4sd3_1
XFILLER_58_333 VPWR VGND VPWR VGND sky130_ef_sc_hd__decap_12
XTAP_TAPCELL_ROW_56_501 VGND VPWR sky130_fd_sc_hd__tapvpwrvgnd_1
XTAP_TAPCELL_ROW_5_167 VGND VPWR sky130_fd_sc_hd__tapvpwrvgnd_1
XFILLER_41_277 VGND VGND VPWR VPWR sky130_fd_sc_hd__decap_3
XFILLER_1_373 VGND VGND VPWR VPWR sky130_fd_sc_hd__decap_4
XTAP_TAPCELL_ROW_62_537 VGND VPWR sky130_fd_sc_hd__tapvpwrvgnd_1
XTAP_TAPCELL_ROW_19_258 VGND VPWR sky130_fd_sc_hd__tapvpwrvgnd_1
X_0894_ u_srf_ctrl.timer\[10\] _0573_ u_srf_ctrl.timer\[11\] VGND VGND VPWR VPWR _0578_
+ sky130_fd_sc_hd__a21o_1
X_0963_ u_srf_ctrl.echo_counter\[11\] net27 _0495_ _0636_ VGND VGND VPWR VPWR _0637_
+ sky130_fd_sc_hd__nand4_2
X_1515_ clknet_leaf_0_clk_10mhz _0041_ net55 VGND VGND VPWR VPWR u_srf_ctrl.timer\[19\]
+ sky130_fd_sc_hd__dfrtp_1
X_1377_ net38 net179 _0394_ VGND VGND VPWR VPWR _0234_ sky130_fd_sc_hd__mux2_1
XFILLER_4_82 VGND VGND VPWR VPWR sky130_fd_sc_hd__fill_2
XTAP_TAPCELL_ROW_2_148 VGND VPWR sky130_fd_sc_hd__tapvpwrvgnd_1
X_1446_ net15 _0434_ _0435_ _0427_ u_srf_ctrl.echo_counter\[4\] VGND VGND VPWR VPWR
+ _0262_ sky130_fd_sc_hd__a32o_1
XFILLER_23_255 VGND VGND VPWR VPWR sky130_fd_sc_hd__decap_3
XFILLER_58_141 VGND VGND VPWR VPWR sky130_fd_sc_hd__decap_4
XFILLER_48_99 VGND VGND VPWR VPWR sky130_fd_sc_hd__decap_4
XFILLER_0_29 VPWR VGND VPWR VGND sky130_ef_sc_hd__decap_12
XFILLER_9_27 VPWR VGND VPWR VGND sky130_ef_sc_hd__decap_12
XTAP_TAPCELL_ROW_16_239 VGND VPWR sky130_fd_sc_hd__tapvpwrvgnd_1
XTAP_TAPCELL_ROW_24_294 VGND VPWR sky130_fd_sc_hd__tapvpwrvgnd_1
XFILLER_13_80 VPWR VGND VPWR VGND sky130_ef_sc_hd__decap_12
XFILLER_37_358 VPWR VGND VPWR VGND sky130_ef_sc_hd__decap_12
X_1162_ net30 net29 net60 _0740_ VGND VGND VPWR VPWR _0741_ sky130_fd_sc_hd__and4_4
X_1300_ u_fifo.mem\[6\]\[1\] _0297_ _0306_ u_fifo.mem\[14\]\[1\] _0330_ VGND VGND
+ VPWR VPWR _0331_ sky130_fd_sc_hd__a221o_1
X_1231_ net76 net42 _0284_ VGND VGND VPWR VPWR _0198_ sky130_fd_sc_hd__mux2_1
XFILLER_1_181 VPWR VGND VPWR VGND sky130_ef_sc_hd__decap_12
X_1093_ distance_out\[2\] _0713_ _0721_ _0663_ VGND VGND VPWR VPWR _0722_ sky130_fd_sc_hd__a22o_1
X_0877_ u_srf_ctrl.timer\[5\] net19 net9 _0566_ VGND VGND VPWR VPWR _0027_ sky130_fd_sc_hd__a22o_1
X_0946_ u_srf_ctrl.echo_counter\[6\] u_srf_ctrl.echo_counter\[2\] u_srf_ctrl.echo_counter\[1\]
+ u_srf_ctrl.echo_counter\[5\] VGND VGND VPWR VPWR _0620_ sky130_fd_sc_hd__a22o_1
XFILLER_20_225 VGND VGND VPWR VPWR sky130_fd_sc_hd__decap_3
X_1429_ _0418_ _0422_ _0423_ _0420_ VGND VGND VPWR VPWR _0424_ sky130_fd_sc_hd__o31a_1
XFILLER_55_166 VGND VGND VPWR VPWR sky130_fd_sc_hd__fill_2
XFILLER_43_306 VGND VGND VPWR VPWR sky130_fd_sc_hd__decap_4
XTAP_TAPCELL_ROW_38_386 VGND VPWR sky130_fd_sc_hd__tapvpwrvgnd_1
XFILLER_28_358 VGND VGND VPWR VPWR sky130_fd_sc_hd__decap_6
XFILLER_28_325 VGND VGND VPWR VPWR sky130_fd_sc_hd__fill_1
Xclkload1 clknet_2_1__leaf_clk_10mhz VGND VGND VPWR VPWR clkload1/X sky130_fd_sc_hd__clkbuf_8
XFILLER_1_3 VPWR VGND VPWR VGND sky130_ef_sc_hd__decap_12
XTAP_TAPCELL_ROW_21_275 VGND VPWR sky130_fd_sc_hd__tapvpwrvgnd_1
XFILLER_46_111 VGND VGND VPWR VPWR sky130_fd_sc_hd__fill_1
X_1780_ u_uart.busy VGND VGND VPWR VPWR net3 sky130_fd_sc_hd__clkbuf_1
X_0800_ u_srf_ctrl.timer\[1\] u_srf_ctrl.timer\[2\] u_srf_ctrl.timer\[3\] VGND VGND
+ VPWR VPWR _0514_ sky130_fd_sc_hd__o21a_1
XFILLER_6_251 VGND VGND VPWR VPWR sky130_fd_sc_hd__fill_1
XFILLER_34_3 VPWR VGND VPWR VGND sky130_ef_sc_hd__decap_12
X_1214_ net139 net41 _0282_ VGND VGND VPWR VPWR _0183_ sky130_fd_sc_hd__mux2_1
X_1145_ net153 net48 _0738_ VGND VGND VPWR VPWR _0123_ sky130_fd_sc_hd__mux2_1
X_1076_ net239 net214 net14 VGND VGND VPWR VPWR _0080_ sky130_fd_sc_hd__mux2_1
XTAP_TAPCELL_ROW_35_367 VGND VPWR sky130_fd_sc_hd__tapvpwrvgnd_1
X_0929_ _0496_ _0602_ VGND VGND VPWR VPWR _0603_ sky130_fd_sc_hd__nand2_1
XFILLER_20_37 VGND VGND VPWR VPWR sky130_fd_sc_hd__fill_2
Xhold68 u_fifo.mem\[12\]\[2\] VGND VGND VPWR VPWR net136 sky130_fd_sc_hd__dlygate4sd3_1
Xhold57 u_fifo.mem\[4\]\[0\] VGND VGND VPWR VPWR net125 sky130_fd_sc_hd__dlygate4sd3_1
Xhold46 u_fifo.mem\[12\]\[1\] VGND VGND VPWR VPWR net114 sky130_fd_sc_hd__dlygate4sd3_1
Xhold35 u_fifo.mem\[2\]\[7\] VGND VGND VPWR VPWR net103 sky130_fd_sc_hd__dlygate4sd3_1
Xhold79 u_fifo.mem\[1\]\[2\] VGND VGND VPWR VPWR net147 sky130_fd_sc_hd__dlygate4sd3_1
Xhold13 u_fifo.mem\[8\]\[6\] VGND VGND VPWR VPWR net81 sky130_fd_sc_hd__dlygate4sd3_1
Xhold24 u_fifo.mem\[2\]\[0\] VGND VGND VPWR VPWR net92 sky130_fd_sc_hd__dlygate4sd3_1
XFILLER_45_67 VPWR VGND VPWR VGND sky130_ef_sc_hd__decap_12
XFILLER_24_361 VGND VGND VPWR VPWR sky130_fd_sc_hd__decap_3
XFILLER_61_55 VGND VGND VPWR VPWR sky130_fd_sc_hd__fill_1
XFILLER_42_191 VGND VGND VPWR VPWR sky130_fd_sc_hd__decap_4
XTAP_TAPCELL_ROW_32_348 VGND VPWR sky130_fd_sc_hd__tapvpwrvgnd_1
XFILLER_22_309 VPWR VGND VPWR VGND sky130_ef_sc_hd__decap_12
X_1694_ clknet_leaf_14_clk_10mhz _0197_ VGND VGND VPWR VPWR u_fifo.mem\[1\]\[3\] sky130_fd_sc_hd__dfxtp_1
X_1763_ clknet_leaf_27_clk_10mhz _0266_ net52 VGND VGND VPWR VPWR u_srf_ctrl.echo_counter\[8\]
+ sky130_fd_sc_hd__dfrtp_2
XFILLER_57_206 VGND VGND VPWR VPWR sky130_fd_sc_hd__decap_8
X_1128_ net138 net43 _0734_ VGND VGND VPWR VPWR _0110_ sky130_fd_sc_hd__mux2_1
X_1059_ net209 net17 VGND VGND VPWR VPWR _0067_ sky130_fd_sc_hd__and2_1
XFILLER_33_191 VGND VGND VPWR VPWR sky130_fd_sc_hd__fill_2
XFILLER_56_33 VGND VGND VPWR VPWR sky130_fd_sc_hd__decap_8
XFILLER_12_320 VPWR VGND VPWR VGND sky130_ef_sc_hd__decap_12
XFILLER_30_183 VGND VGND VPWR VPWR sky130_fd_sc_hd__decap_4
X_1677_ clknet_leaf_8_clk_10mhz _0180_ VGND VGND VPWR VPWR u_fifo.mem\[12\]\[2\] sky130_fd_sc_hd__dfxtp_1
X_1746_ clknet_leaf_5_clk_10mhz _0249_ net62 VGND VGND VPWR VPWR u_uart.clk_count\[6\]
+ sky130_fd_sc_hd__dfrtp_1
XFILLER_7_93 VGND VGND VPWR VPWR sky130_fd_sc_hd__fill_2
XFILLER_38_261 VGND VGND VPWR VPWR sky130_fd_sc_hd__decap_4
XFILLER_5_349 VPWR VGND VPWR VGND sky130_ef_sc_hd__decap_12
XFILLER_5_316 VPWR VGND VPWR VGND sky130_ef_sc_hd__decap_12
XFILLER_5_305 VGND VGND VPWR VPWR sky130_fd_sc_hd__decap_4
XTAP_TAPCELL_ROW_59_521 VGND VPWR sky130_fd_sc_hd__tapvpwrvgnd_1
XTAP_TAPCELL_ROW_8_187 VGND VPWR sky130_fd_sc_hd__tapvpwrvgnd_1
XTAP_TAPCELL_ROW_42_410 VGND VPWR sky130_fd_sc_hd__tapvpwrvgnd_1
XFILLER_8_132 VGND VGND VPWR VPWR sky130_fd_sc_hd__decap_8
X_1600_ clknet_leaf_24_clk_10mhz _0103_ VGND VGND VPWR VPWR u_fifo.mem\[11\]\[5\]
+ sky130_fd_sc_hd__dfxtp_1
X_1462_ _0550_ _0446_ _0447_ VGND VGND VPWR VPWR _0266_ sky130_fd_sc_hd__nor3_1
X_1531_ clknet_leaf_23_clk_10mhz _0056_ net22 VGND VGND VPWR VPWR u_packet_assembler.timer\[11\]
+ sky130_fd_sc_hd__dfrtp_1
X_1393_ u_uart.clk_count\[13\] u_uart.clk_count\[12\] u_uart.clk_count\[11\] u_uart.clk_count\[10\]
+ VGND VGND VPWR VPWR _0402_ sky130_fd_sc_hd__or4_1
Xhold110 fifo_dout\[1\] VGND VGND VPWR VPWR net178 sky130_fd_sc_hd__dlygate4sd3_1
X_1729_ clknet_leaf_12_clk_10mhz _0232_ VGND VGND VPWR VPWR u_fifo.mem\[13\]\[4\]
+ sky130_fd_sc_hd__dfxtp_1
Xhold121 u_fifo.mem\[9\]\[3\] VGND VGND VPWR VPWR net189 sky130_fd_sc_hd__dlygate4sd3_1
Xhold154 u_uart.tx_data_reg\[6\] VGND VGND VPWR VPWR net222 sky130_fd_sc_hd__dlygate4sd3_1
Xhold143 fifo_dout\[6\] VGND VGND VPWR VPWR net211 sky130_fd_sc_hd__dlygate4sd3_1
Xhold132 u_fifo.mem\[1\]\[3\] VGND VGND VPWR VPWR net200 sky130_fd_sc_hd__dlygate4sd3_1
Xhold198 u_packet_assembler.timer\[9\] VGND VGND VPWR VPWR net266 sky130_fd_sc_hd__dlygate4sd3_1
Xhold187 u_packet_assembler.timer\[12\] VGND VGND VPWR VPWR net255 sky130_fd_sc_hd__dlygate4sd3_1
Xhold176 u_max30102_ctrl.clk_div\[11\] VGND VGND VPWR VPWR net244 sky130_fd_sc_hd__dlygate4sd3_1
Xhold165 distance_out\[1\] VGND VGND VPWR VPWR net233 sky130_fd_sc_hd__dlygate4sd3_1
XFILLER_58_345 VPWR VGND VPWR VGND sky130_ef_sc_hd__decap_12
XTAP_TAPCELL_ROW_56_502 VGND VPWR sky130_fd_sc_hd__tapvpwrvgnd_1
XFILLER_37_79 VGND VGND VPWR VPWR sky130_fd_sc_hd__decap_3
XTAP_TAPCELL_ROW_5_168 VGND VPWR sky130_fd_sc_hd__tapvpwrvgnd_1
XFILLER_18_209 VGND VGND VPWR VPWR sky130_fd_sc_hd__decap_8
XFILLER_53_67 VGND VGND VPWR VPWR sky130_fd_sc_hd__decap_4
XFILLER_41_289 VGND VGND VPWR VPWR sky130_fd_sc_hd__decap_4
XFILLER_5_146 VGND VGND VPWR VPWR sky130_fd_sc_hd__fill_2
XTAP_TAPCELL_ROW_62_538 VGND VPWR sky130_fd_sc_hd__tapvpwrvgnd_1
XTAP_TAPCELL_ROW_19_259 VGND VPWR sky130_fd_sc_hd__tapvpwrvgnd_1
X_0893_ u_srf_ctrl.timer\[11\] u_srf_ctrl.timer\[10\] _0573_ VGND VGND VPWR VPWR _0577_
+ sky130_fd_sc_hd__nand3_1
X_0962_ u_srf_ctrl.echo_counter\[12\] u_srf_ctrl.echo_counter\[8\] VGND VGND VPWR
+ VPWR _0636_ sky130_fd_sc_hd__nand2_1
XFILLER_59_109 VGND VGND VPWR VPWR sky130_fd_sc_hd__decap_3
X_1514_ clknet_leaf_0_clk_10mhz _0040_ net55 VGND VGND VPWR VPWR u_srf_ctrl.timer\[18\]
+ sky130_fd_sc_hd__dfrtp_1
X_1445_ u_srf_ctrl.echo_counter\[4\] net28 _0429_ VGND VGND VPWR VPWR _0435_ sky130_fd_sc_hd__nand3_1
X_1376_ net41 net185 _0394_ VGND VGND VPWR VPWR _0233_ sky130_fd_sc_hd__mux2_1
XFILLER_55_337 VPWR VGND VPWR VGND sky130_ef_sc_hd__decap_12
XTAP_TAPCELL_ROW_2_149 VGND VPWR sky130_fd_sc_hd__tapvpwrvgnd_1
XFILLER_48_89 VGND VGND VPWR VPWR sky130_fd_sc_hd__fill_1
XFILLER_46_304 VGND VGND VPWR VPWR sky130_fd_sc_hd__decap_4
XFILLER_2_149 VGND VGND VPWR VPWR sky130_fd_sc_hd__decap_3
Xfanout60 net61 VGND VGND VPWR VPWR net60 sky130_fd_sc_hd__buf_2
XFILLER_9_39 VGND VGND VPWR VPWR sky130_fd_sc_hd__decap_6
XFILLER_13_92 VPWR VGND VPWR VGND sky130_ef_sc_hd__decap_12
XTAP_TAPCELL_ROW_24_295 VGND VPWR sky130_fd_sc_hd__tapvpwrvgnd_1
X_1230_ net200 net45 _0284_ VGND VGND VPWR VPWR _0197_ sky130_fd_sc_hd__mux2_1
X_1161_ u_fifo.wr_ptr\[3\] _0709_ u_fifo.wr_ptr\[2\] VGND VGND VPWR VPWR _0740_ sky130_fd_sc_hd__and3b_1
XFILLER_1_193 VPWR VGND VPWR VGND sky130_ef_sc_hd__decap_12
X_1092_ _0714_ _0720_ VGND VGND VPWR VPWR _0721_ sky130_fd_sc_hd__or2_1
X_0876_ u_srf_ctrl.timer\[5\] _0564_ VGND VGND VPWR VPWR _0566_ sky130_fd_sc_hd__xnor2_1
X_0945_ u_srf_ctrl.echo_counter\[5\] u_srf_ctrl.echo_counter\[1\] u_srf_ctrl.echo_counter\[0\]
+ u_srf_ctrl.echo_counter\[4\] VGND VGND VPWR VPWR _0619_ sky130_fd_sc_hd__o211a_1
X_1428_ u_uart.tx_data_reg\[7\] _0417_ _0421_ _0473_ _0472_ VGND VGND VPWR VPWR _0423_
+ sky130_fd_sc_hd__a221o_1
XFILLER_18_15 VPWR VGND VPWR VGND sky130_ef_sc_hd__decap_12
X_1359_ u_fifo.mem\[15\]\[7\] _0291_ _0311_ u_fifo.mem\[4\]\[7\] VGND VGND VPWR VPWR
+ _0384_ sky130_fd_sc_hd__a22o_1
XTAP_TAPCELL_ROW_38_387 VGND VPWR sky130_fd_sc_hd__tapvpwrvgnd_1
XFILLER_34_36 VPWR VGND VPWR VGND sky130_ef_sc_hd__decap_12
Xclkload2 clknet_2_3__leaf_clk_10mhz VGND VGND VPWR VPWR clkload2/X sky130_fd_sc_hd__clkbuf_8
XTAP_TAPCELL_ROW_21_276 VGND VPWR sky130_fd_sc_hd__tapvpwrvgnd_1
XFILLER_19_337 VPWR VGND VPWR VGND sky130_ef_sc_hd__decap_12
X_1213_ net109 net42 _0282_ VGND VGND VPWR VPWR _0182_ sky130_fd_sc_hd__mux2_1
X_1144_ net141 net50 _0738_ VGND VGND VPWR VPWR _0122_ sky130_fd_sc_hd__mux2_1
X_1075_ net225 net187 _0004_ VGND VGND VPWR VPWR _0079_ sky130_fd_sc_hd__mux2_1
XFILLER_1_51 VGND VGND VPWR VPWR sky130_fd_sc_hd__decap_4
XFILLER_60_192 VGND VGND VPWR VPWR sky130_fd_sc_hd__decap_4
XFILLER_60_181 VGND VGND VPWR VPWR sky130_fd_sc_hd__fill_2
X_0859_ _0476_ _0553_ VGND VGND VPWR VPWR _0554_ sky130_fd_sc_hd__and2_1
X_0928_ u_srf_ctrl.echo_counter\[14\] u_srf_ctrl.echo_counter\[10\] VGND VGND VPWR
+ VPWR _0602_ sky130_fd_sc_hd__nand2_1
Xhold47 u_fifo.mem\[8\]\[7\] VGND VGND VPWR VPWR net115 sky130_fd_sc_hd__dlygate4sd3_1
Xhold69 u_fifo.mem\[1\]\[1\] VGND VGND VPWR VPWR net137 sky130_fd_sc_hd__dlygate4sd3_1
Xhold58 u_fifo.mem\[3\]\[6\] VGND VGND VPWR VPWR net126 sky130_fd_sc_hd__dlygate4sd3_1
Xhold14 u_fifo.mem\[14\]\[3\] VGND VGND VPWR VPWR net82 sky130_fd_sc_hd__dlygate4sd3_1
Xhold36 u_fifo.mem\[14\]\[7\] VGND VGND VPWR VPWR net104 sky130_fd_sc_hd__dlygate4sd3_1
Xhold25 u_fifo.mem\[6\]\[0\] VGND VGND VPWR VPWR net93 sky130_fd_sc_hd__dlygate4sd3_1
XFILLER_45_79 VPWR VGND VPWR VGND sky130_ef_sc_hd__decap_12
XFILLER_45_57 VGND VGND VPWR VPWR sky130_fd_sc_hd__decap_4
XFILLER_45_46 VGND VGND VPWR VPWR sky130_fd_sc_hd__decap_8
XFILLER_3_288 VGND VGND VPWR VPWR sky130_fd_sc_hd__decap_8
XFILLER_30_365 VPWR VGND VPWR VGND sky130_ef_sc_hd__decap_12
X_1693_ clknet_leaf_15_clk_10mhz _0196_ VGND VGND VPWR VPWR u_fifo.mem\[1\]\[2\] sky130_fd_sc_hd__dfxtp_1
X_1762_ clknet_leaf_1_clk_10mhz _0265_ net54 VGND VGND VPWR VPWR u_srf_ctrl.echo_counter\[7\]
+ sky130_fd_sc_hd__dfrtp_1
X_1127_ net96 net44 _0734_ VGND VGND VPWR VPWR _0109_ sky130_fd_sc_hd__mux2_1
XFILLER_15_38 VGND VGND VPWR VPWR sky130_fd_sc_hd__decap_3
X_1058_ net221 net17 VGND VGND VPWR VPWR _0066_ sky130_fd_sc_hd__and2_1
XFILLER_31_48 VGND VGND VPWR VPWR sky130_fd_sc_hd__decap_8
XPHY_EDGE_ROW_1_Right_1 VGND VGND VPWR VPWR sky130_fd_sc_hd__decap_3
XFILLER_0_225 VPWR VGND VPWR VGND sky130_ef_sc_hd__decap_12
XTAP_TAPCELL_ROW_54_485 VGND VPWR sky130_fd_sc_hd__tapvpwrvgnd_1
XFILLER_12_332 VGND VGND VPWR VPWR sky130_fd_sc_hd__decap_8
XFILLER_12_365 VPWR VGND VPWR VGND sky130_ef_sc_hd__decap_12
XFILLER_24_181 VGND VGND VPWR VPWR sky130_fd_sc_hd__fill_2
XFILLER_24_192 VGND VGND VPWR VPWR sky130_fd_sc_hd__decap_4
XTAP_TAPCELL_ROW_45_430 VGND VPWR sky130_fd_sc_hd__tapvpwrvgnd_1
X_1745_ clknet_leaf_6_clk_10mhz _0248_ net62 VGND VGND VPWR VPWR u_uart.clk_count\[5\]
+ sky130_fd_sc_hd__dfrtp_1
X_1676_ clknet_leaf_10_clk_10mhz _0179_ VGND VGND VPWR VPWR u_fifo.mem\[12\]\[1\]
+ sky130_fd_sc_hd__dfxtp_1
Xclkbuf_leaf_0_clk_10mhz clknet_2_0__leaf_clk_10mhz VGND VGND VPWR VPWR clknet_leaf_0_clk_10mhz
+ sky130_fd_sc_hd__clkbuf_8
XTAP_TAPCELL_ROW_51_466 VGND VPWR sky130_fd_sc_hd__tapvpwrvgnd_1
XFILLER_5_328 VGND VGND VPWR VPWR sky130_fd_sc_hd__decap_8
XTAP_TAPCELL_ROW_59_522 VGND VPWR sky130_fd_sc_hd__tapvpwrvgnd_1
XTAP_TAPCELL_ROW_8_188 VGND VPWR sky130_fd_sc_hd__tapvpwrvgnd_1
XTAP_TAPCELL_ROW_42_411 VGND VPWR sky130_fd_sc_hd__tapvpwrvgnd_1
XFILLER_29_295 VGND VGND VPWR VPWR sky130_fd_sc_hd__fill_1
X_1392_ u_uart.clk_count\[4\] _0400_ u_uart.clk_count\[5\] VGND VGND VPWR VPWR _0401_
+ sky130_fd_sc_hd__a21o_1
X_1461_ u_srf_ctrl.echo_counter\[8\] _0444_ VGND VGND VPWR VPWR _0447_ sky130_fd_sc_hd__and2_1
X_1530_ clknet_leaf_22_clk_10mhz _0055_ net20 VGND VGND VPWR VPWR u_packet_assembler.timer\[10\]
+ sky130_fd_sc_hd__dfrtp_1
XFILLER_35_221 VGND VGND VPWR VPWR sky130_fd_sc_hd__decap_3
XFILLER_50_213 VGND VGND VPWR VPWR sky130_fd_sc_hd__decap_3
XFILLER_35_287 VGND VGND VPWR VPWR sky130_fd_sc_hd__fill_1
Xhold122 u_fifo.mem\[5\]\[5\] VGND VGND VPWR VPWR net190 sky130_fd_sc_hd__dlygate4sd3_1
Xhold133 u_uart.tx_data_reg\[1\] VGND VGND VPWR VPWR net201 sky130_fd_sc_hd__dlygate4sd3_1
Xhold111 u_fifo.mem\[13\]\[6\] VGND VGND VPWR VPWR net179 sky130_fd_sc_hd__dlygate4sd3_1
X_1728_ clknet_leaf_16_clk_10mhz _0231_ VGND VGND VPWR VPWR u_fifo.mem\[13\]\[3\]
+ sky130_fd_sc_hd__dfxtp_1
Xhold100 u_fifo.mem\[15\]\[3\] VGND VGND VPWR VPWR net168 sky130_fd_sc_hd__dlygate4sd3_1
XFILLER_2_309 VPWR VGND VPWR VGND sky130_ef_sc_hd__decap_12
Xhold144 u_packet_assembler.timer\[23\] VGND VGND VPWR VPWR net212 sky130_fd_sc_hd__dlygate4sd3_1
Xhold166 u_uart.clk_count\[0\] VGND VGND VPWR VPWR net234 sky130_fd_sc_hd__dlygate4sd3_1
XFILLER_58_357 VGND VGND VPWR VPWR sky130_fd_sc_hd__decap_6
X_1659_ clknet_leaf_8_clk_10mhz _0162_ VGND VGND VPWR VPWR u_fifo.mem\[4\]\[0\] sky130_fd_sc_hd__dfxtp_1
Xhold155 u_uart.clk_count\[10\] VGND VGND VPWR VPWR net223 sky130_fd_sc_hd__dlygate4sd3_1
Xhold177 u_packet_assembler.timer\[3\] VGND VGND VPWR VPWR net245 sky130_fd_sc_hd__dlygate4sd3_1
Xhold188 distance_out\[5\] VGND VGND VPWR VPWR net256 sky130_fd_sc_hd__dlygate4sd3_1
XTAP_TAPCELL_ROW_5_169 VGND VPWR sky130_fd_sc_hd__tapvpwrvgnd_1
Xhold199 u_packet_assembler.timer\[14\] VGND VGND VPWR VPWR net267 sky130_fd_sc_hd__dlygate4sd3_1
XTAP_TAPCELL_ROW_56_503 VGND VPWR sky130_fd_sc_hd__tapvpwrvgnd_1
XFILLER_37_36 VGND VGND VPWR VPWR sky130_fd_sc_hd__decap_8
XFILLER_53_57 VGND VGND VPWR VPWR sky130_fd_sc_hd__decap_4
XTAP_TAPCELL_ROW_62_539 VGND VPWR sky130_fd_sc_hd__tapvpwrvgnd_1
X_0961_ _0627_ _0630_ _0626_ VGND VGND VPWR VPWR _0635_ sky130_fd_sc_hd__a21o_1
XFILLER_57_3 VGND VGND VPWR VPWR sky130_fd_sc_hd__decap_8
X_0892_ u_srf_ctrl.timer\[10\] _0554_ net9 _0576_ VGND VGND VPWR VPWR _0032_ sky130_fd_sc_hd__a22o_1
X_1375_ net43 net167 _0394_ VGND VGND VPWR VPWR _0232_ sky130_fd_sc_hd__mux2_1
X_1513_ clknet_leaf_4_clk_10mhz _0039_ net58 VGND VGND VPWR VPWR u_srf_ctrl.timer\[17\]
+ sky130_fd_sc_hd__dfrtp_1
XFILLER_4_62 VPWR VGND VPWR VGND sky130_ef_sc_hd__decap_12
X_1444_ net28 _0429_ u_srf_ctrl.echo_counter\[4\] VGND VGND VPWR VPWR _0434_ sky130_fd_sc_hd__a21o_1
XFILLER_55_349 VPWR VGND VPWR VGND sky130_ef_sc_hd__decap_12
XFILLER_2_139 VGND VGND VPWR VPWR sky130_fd_sc_hd__fill_1
XFILLER_46_349 VPWR VGND VPWR VGND sky130_ef_sc_hd__decap_12
XFILLER_14_257 VPWR VGND VPWR VGND sky130_ef_sc_hd__decap_12
Xfanout50 net51 VGND VGND VPWR VPWR net50 sky130_fd_sc_hd__buf_2
Xfanout61 net65 VGND VGND VPWR VPWR net61 sky130_fd_sc_hd__clkbuf_4
XTAP_TAPCELL_ROW_24_296 VGND VPWR sky130_fd_sc_hd__tapvpwrvgnd_1
XFILLER_49_121 VGND VGND VPWR VPWR sky130_fd_sc_hd__decap_3
XFILLER_49_110 VGND VGND VPWR VPWR sky130_fd_sc_hd__fill_2
XFILLER_37_316 VPWR VGND VPWR VGND sky130_ef_sc_hd__decap_12
X_1091_ _0477_ u_packet_assembler.state\[3\] _0478_ VGND VGND VPWR VPWR _0720_ sky130_fd_sc_hd__and3_1
X_1160_ net104 net37 _0739_ VGND VGND VPWR VPWR _0137_ sky130_fd_sc_hd__mux2_1
XFILLER_60_363 VGND VGND VPWR VPWR sky130_fd_sc_hd__fill_1
X_0944_ _0612_ _0617_ VGND VGND VPWR VPWR _0618_ sky130_fd_sc_hd__nor2_1
X_0875_ net9 _0564_ _0565_ net19 u_srf_ctrl.timer\[4\] VGND VGND VPWR VPWR _0026_
+ sky130_fd_sc_hd__a32o_1
Xclkload20 clknet_leaf_23_clk_10mhz VGND VGND VPWR VPWR clkload20/Y sky130_fd_sc_hd__inv_6
XFILLER_55_113 VGND VGND VPWR VPWR sky130_fd_sc_hd__fill_1
X_1427_ u_uart.bit_index\[0\] u_uart.tx_data_reg\[6\] u_uart.bit_index\[1\] VGND VGND
+ VPWR VPWR _0422_ sky130_fd_sc_hd__and3b_1
X_1358_ _0383_ net211 _0296_ VGND VGND VPWR VPWR _0226_ sky130_fd_sc_hd__mux2_1
XFILLER_18_27 VGND VGND VPWR VPWR sky130_fd_sc_hd__fill_1
X_1289_ _0317_ _0318_ _0319_ _0320_ VGND VGND VPWR VPWR _0321_ sky130_fd_sc_hd__or4_1
XFILLER_34_48 VGND VGND VPWR VPWR sky130_fd_sc_hd__decap_8
XFILLER_34_15 VGND VGND VPWR VPWR sky130_fd_sc_hd__decap_4
Xclkload3 clknet_leaf_0_clk_10mhz VGND VGND VPWR VPWR clkload3/Y sky130_fd_sc_hd__inv_8
XFILLER_59_45 VGND VGND VPWR VPWR sky130_fd_sc_hd__decap_6
XFILLER_19_305 VPWR VGND VPWR VGND sky130_ef_sc_hd__decap_12
XFILLER_19_349 VPWR VGND VPWR VGND sky130_ef_sc_hd__decap_12
XFILLER_61_149 VGND VGND VPWR VPWR sky130_fd_sc_hd__decap_3
XFILLER_42_363 VGND VGND VPWR VPWR sky130_fd_sc_hd__fill_1
X_1212_ net108 net45 _0282_ VGND VGND VPWR VPWR _0181_ sky130_fd_sc_hd__mux2_1
XFILLER_52_105 VGND VGND VPWR VPWR sky130_fd_sc_hd__decap_8
X_1074_ net201 net178 net14 VGND VGND VPWR VPWR _0078_ sky130_fd_sc_hd__mux2_1
X_1143_ _0709_ _0732_ _0737_ VGND VGND VPWR VPWR _0738_ sky130_fd_sc_hd__and3_4
X_0927_ net262 _0476_ _0599_ _0601_ VGND VGND VPWR VPWR _0042_ sky130_fd_sc_hd__o31ai_1
X_0789_ u_srf_ctrl.timer\[5\] u_srf_ctrl.timer\[4\] _0503_ u_srf_ctrl.timer\[6\] u_srf_ctrl.timer\[7\]
+ VGND VGND VPWR VPWR _0504_ sky130_fd_sc_hd__a311o_1
XFILLER_29_26 VPWR VGND VPWR VGND sky130_ef_sc_hd__decap_12
XFILLER_29_15 VGND VGND VPWR VPWR sky130_fd_sc_hd__decap_8
X_0858_ u_srf_ctrl.state\[0\] u_srf_ctrl.state\[2\] VGND VGND VPWR VPWR _0553_ sky130_fd_sc_hd__nor2_1
Xhold26 u_fifo.mem\[3\]\[7\] VGND VGND VPWR VPWR net94 sky130_fd_sc_hd__dlygate4sd3_1
Xhold59 u_fifo.mem\[7\]\[1\] VGND VGND VPWR VPWR net127 sky130_fd_sc_hd__dlygate4sd3_1
Xhold15 u_fifo.mem\[7\]\[5\] VGND VGND VPWR VPWR net83 sky130_fd_sc_hd__dlygate4sd3_1
Xhold48 u_fifo.mem\[2\]\[1\] VGND VGND VPWR VPWR net116 sky130_fd_sc_hd__dlygate4sd3_1
Xhold37 u_fifo.mem\[1\]\[5\] VGND VGND VPWR VPWR net105 sky130_fd_sc_hd__dlygate4sd3_1
XTAP_TAPCELL_ROW_26_303 VGND VPWR sky130_fd_sc_hd__tapvpwrvgnd_1
XFILLER_61_57 VGND VGND VPWR VPWR sky130_fd_sc_hd__decap_8
XFILLER_43_127 VPWR VGND VPWR VGND sky130_ef_sc_hd__decap_12
XFILLER_3_223 VGND VGND VPWR VPWR sky130_fd_sc_hd__fill_1
XFILLER_34_105 VGND VGND VPWR VPWR sky130_fd_sc_hd__decap_6
XTAP_TAPCELL_ROW_40_394 VGND VPWR sky130_fd_sc_hd__tapvpwrvgnd_1
XFILLER_15_374 VGND VGND VPWR VPWR sky130_fd_sc_hd__decap_3
X_1761_ clknet_leaf_28_clk_10mhz _0264_ net54 VGND VGND VPWR VPWR u_srf_ctrl.echo_counter\[6\]
+ sky130_fd_sc_hd__dfrtp_2
X_1692_ clknet_leaf_15_clk_10mhz _0195_ VGND VGND VPWR VPWR u_fifo.mem\[1\]\[1\] sky130_fd_sc_hd__dfxtp_1
X_1126_ net171 net47 _0734_ VGND VGND VPWR VPWR _0108_ sky130_fd_sc_hd__mux2_1
XTAP_TAPCELL_ROW_48_450 VGND VPWR sky130_fd_sc_hd__tapvpwrvgnd_1
X_1057_ net206 net17 VGND VGND VPWR VPWR _0065_ sky130_fd_sc_hd__and2_1
XFILLER_0_237 VPWR VGND VPWR VGND sky130_ef_sc_hd__decap_12
XTAP_TAPCELL_ROW_54_486 VGND VPWR sky130_fd_sc_hd__tapvpwrvgnd_1
XFILLER_31_119 VGND VGND VPWR VPWR sky130_fd_sc_hd__decap_4
XFILLER_8_304 VGND VGND VPWR VPWR sky130_fd_sc_hd__fill_1
XFILLER_8_315 VGND VGND VPWR VPWR sky130_fd_sc_hd__decap_6
XTAP_TAPCELL_ROW_45_431 VGND VPWR sky130_fd_sc_hd__tapvpwrvgnd_1
XFILLER_15_193 VPWR VGND VPWR VGND sky130_ef_sc_hd__decap_12
X_1744_ clknet_leaf_6_clk_10mhz _0247_ net63 VGND VGND VPWR VPWR u_uart.clk_count\[4\]
+ sky130_fd_sc_hd__dfrtp_1
XFILLER_30_141 VGND VGND VPWR VPWR sky130_fd_sc_hd__decap_4
XPHY_EDGE_ROW_15_Left_79 VGND VGND VPWR VPWR sky130_fd_sc_hd__decap_3
X_1675_ clknet_leaf_12_clk_10mhz _0178_ VGND VGND VPWR VPWR u_fifo.mem\[12\]\[0\]
+ sky130_fd_sc_hd__dfxtp_1
XPHY_EDGE_ROW_15_Right_15 VGND VGND VPWR VPWR sky130_fd_sc_hd__decap_3
XFILLER_38_274 VGND VGND VPWR VPWR sky130_fd_sc_hd__decap_4
X_1109_ _0730_ _0731_ _0477_ VGND VGND VPWR VPWR _0094_ sky130_fd_sc_hd__mux2_1
XPHY_EDGE_ROW_24_Right_24 VGND VGND VPWR VPWR sky130_fd_sc_hd__decap_3
XFILLER_26_27 VGND VGND VPWR VPWR sky130_fd_sc_hd__fill_1
XFILLER_26_49 VGND VGND VPWR VPWR sky130_fd_sc_hd__fill_2
XTAP_TAPCELL_ROW_51_467 VGND VPWR sky130_fd_sc_hd__tapvpwrvgnd_1
Xclkbuf_leaf_4_clk_10mhz clknet_2_1__leaf_clk_10mhz VGND VGND VPWR VPWR clknet_leaf_4_clk_10mhz
+ sky130_fd_sc_hd__clkbuf_8
XFILLER_21_185 VPWR VGND VPWR VGND sky130_ef_sc_hd__decap_12
XPHY_EDGE_ROW_33_Right_33 VGND VGND VPWR VPWR sky130_fd_sc_hd__decap_3
XTAP_TAPCELL_ROW_59_523 VGND VPWR sky130_fd_sc_hd__tapvpwrvgnd_1
XTAP_TAPCELL_ROW_8_189 VGND VPWR sky130_fd_sc_hd__tapvpwrvgnd_1
XPHY_EDGE_ROW_42_Right_42 VGND VGND VPWR VPWR sky130_fd_sc_hd__decap_3
XTAP_TAPCELL_ROW_42_412 VGND VPWR sky130_fd_sc_hd__tapvpwrvgnd_1
XPHY_EDGE_ROW_51_Right_51 VGND VGND VPWR VPWR sky130_fd_sc_hd__decap_3
XFILLER_32_92 VPWR VGND VPWR VGND sky130_ef_sc_hd__decap_12
XFILLER_12_141 VPWR VGND VPWR VGND sky130_ef_sc_hd__decap_12
X_1391_ u_uart.clk_count\[2\] u_uart.clk_count\[1\] u_uart.clk_count\[3\] VGND VGND
+ VPWR VPWR _0400_ sky130_fd_sc_hd__a21o_1
XFILLER_4_362 VGND VGND VPWR VPWR sky130_fd_sc_hd__fill_2
X_1460_ u_srf_ctrl.echo_counter\[8\] _0444_ VGND VGND VPWR VPWR _0446_ sky130_fd_sc_hd__nor2_1
XPHY_EDGE_ROW_60_Right_60 VGND VGND VPWR VPWR sky130_fd_sc_hd__decap_3
X_1727_ clknet_leaf_8_clk_10mhz _0230_ VGND VGND VPWR VPWR u_fifo.mem\[13\]\[2\] sky130_fd_sc_hd__dfxtp_1
Xhold156 fifo_dout\[4\] VGND VGND VPWR VPWR net224 sky130_fd_sc_hd__dlygate4sd3_1
X_1658_ clknet_leaf_13_clk_10mhz _0161_ VGND VGND VPWR VPWR u_fifo.mem\[5\]\[7\] sky130_fd_sc_hd__dfxtp_1
Xhold123 u_fifo.mem\[15\]\[4\] VGND VGND VPWR VPWR net191 sky130_fd_sc_hd__dlygate4sd3_1
Xhold145 u_fifo.mem\[13\]\[1\] VGND VGND VPWR VPWR net213 sky130_fd_sc_hd__dlygate4sd3_1
Xhold112 u_fifo.mem\[4\]\[4\] VGND VGND VPWR VPWR net180 sky130_fd_sc_hd__dlygate4sd3_1
Xhold134 u_fifo.mem\[9\]\[5\] VGND VGND VPWR VPWR net202 sky130_fd_sc_hd__dlygate4sd3_1
Xhold101 u_fifo.mem\[14\]\[6\] VGND VGND VPWR VPWR net169 sky130_fd_sc_hd__dlygate4sd3_1
Xhold167 net7 VGND VGND VPWR VPWR net235 sky130_fd_sc_hd__dlygate4sd3_1
XTAP_TAPCELL_ROW_56_504 VGND VPWR sky130_fd_sc_hd__tapvpwrvgnd_1
Xhold189 u_uart.state\[0\] VGND VGND VPWR VPWR net257 sky130_fd_sc_hd__dlygate4sd3_1
Xhold178 u_max30102_ctrl.clk_div\[10\] VGND VGND VPWR VPWR net246 sky130_fd_sc_hd__dlygate4sd3_1
X_1589_ clknet_leaf_25_clk_10mhz _0093_ net21 VGND VGND VPWR VPWR fifo_din\[7\] sky130_fd_sc_hd__dfrtp_1
XFILLER_5_126 VPWR VGND VPWR VGND sky130_ef_sc_hd__decap_12
XFILLER_49_314 VGND VGND VPWR VPWR sky130_fd_sc_hd__fill_2
XFILLER_49_325 VGND VGND VPWR VPWR sky130_fd_sc_hd__fill_2
X_0960_ _0623_ _0624_ _0632_ VGND VGND VPWR VPWR _0634_ sky130_fd_sc_hd__a21bo_1
X_0891_ u_srf_ctrl.timer\[10\] _0573_ VGND VGND VPWR VPWR _0576_ sky130_fd_sc_hd__xor2_1
X_1512_ clknet_leaf_4_clk_10mhz _0038_ net58 VGND VGND VPWR VPWR u_srf_ctrl.timer\[16\]
+ sky130_fd_sc_hd__dfrtp_1
X_1374_ net44 net148 _0394_ VGND VGND VPWR VPWR _0231_ sky130_fd_sc_hd__mux2_1
XFILLER_4_74 VGND VGND VPWR VPWR sky130_fd_sc_hd__decap_8
X_1443_ net15 _0432_ _0433_ _0427_ net28 VGND VGND VPWR VPWR _0261_ sky130_fd_sc_hd__a32o_1
XFILLER_63_361 VGND VGND VPWR VPWR sky130_fd_sc_hd__decap_3
XFILLER_23_225 VPWR VGND VPWR VGND sky130_ef_sc_hd__decap_12
XPHY_EDGE_ROW_18_Left_82 VGND VGND VPWR VPWR sky130_fd_sc_hd__decap_3
XFILLER_58_166 VGND VGND VPWR VPWR sky130_fd_sc_hd__fill_1
XFILLER_46_328 VGND VGND VPWR VPWR sky130_fd_sc_hd__decap_4
XPHY_EDGE_ROW_45_Left_109 VGND VGND VPWR VPWR sky130_fd_sc_hd__decap_3
XFILLER_54_361 VGND VGND VPWR VPWR sky130_fd_sc_hd__decap_3
XPHY_EDGE_ROW_54_Left_118 VGND VGND VPWR VPWR sky130_fd_sc_hd__decap_3
Xfanout62 net64 VGND VGND VPWR VPWR net62 sky130_fd_sc_hd__clkbuf_4
XFILLER_14_236 VGND VGND VPWR VPWR sky130_fd_sc_hd__decap_6
XFILLER_14_269 VGND VGND VPWR VPWR sky130_fd_sc_hd__fill_1
Xfanout51 fifo_din\[0\] VGND VGND VPWR VPWR net51 sky130_fd_sc_hd__buf_2
Xfanout40 net41 VGND VGND VPWR VPWR net40 sky130_fd_sc_hd__buf_2
XFILLER_13_50 VGND VGND VPWR VPWR sky130_fd_sc_hd__fill_1
XPHY_EDGE_ROW_63_Left_127 VGND VGND VPWR VPWR sky130_fd_sc_hd__decap_3
XFILLER_52_309 VGND VGND VPWR VPWR sky130_fd_sc_hd__decap_4
XFILLER_45_361 VPWR VGND VPWR VGND sky130_ef_sc_hd__decap_12
XFILLER_37_328 VGND VGND VPWR VPWR sky130_fd_sc_hd__decap_8
X_1090_ net49 _0021_ _0717_ _0719_ VGND VGND VPWR VPWR _0087_ sky130_fd_sc_hd__o22a_1
Xclkload10 clknet_leaf_4_clk_10mhz VGND VGND VPWR VPWR clkload10/Y sky130_fd_sc_hd__inv_6
X_0874_ u_srf_ctrl.timer\[4\] _0561_ VGND VGND VPWR VPWR _0565_ sky130_fd_sc_hd__or2_1
X_0943_ _0609_ _0614_ VGND VGND VPWR VPWR _0617_ sky130_fd_sc_hd__xnor2_1
XFILLER_20_217 VGND VGND VPWR VPWR sky130_fd_sc_hd__decap_8
Xclkload21 clknet_leaf_24_clk_10mhz VGND VGND VPWR VPWR clkload21/Y sky130_fd_sc_hd__bufinv_16
X_1426_ u_uart.tx_data_reg\[4\] u_uart.tx_data_reg\[5\] u_uart.bit_index\[0\] VGND
+ VGND VPWR VPWR _0421_ sky130_fd_sc_hd__mux2_1
X_1357_ u_fifo.mem\[0\]\[6\] _0322_ _0378_ _0382_ VGND VGND VPWR VPWR _0383_ sky130_fd_sc_hd__o22a_1
X_1288_ u_fifo.mem\[6\]\[0\] _0297_ _0306_ u_fifo.mem\[14\]\[0\] _0304_ VGND VGND
+ VPWR VPWR _0320_ sky130_fd_sc_hd__a221o_1
XFILLER_55_169 VPWR VGND VPWR VGND sky130_ef_sc_hd__decap_12
XFILLER_51_331 VGND VGND VPWR VPWR sky130_fd_sc_hd__decap_4
XFILLER_36_350 VPWR VGND VPWR VGND sky130_ef_sc_hd__decap_12
XFILLER_34_27 VGND VGND VPWR VPWR sky130_fd_sc_hd__fill_1
XFILLER_50_59 VGND VGND VPWR VPWR sky130_fd_sc_hd__fill_1
XFILLER_50_37 VGND VGND VPWR VPWR sky130_fd_sc_hd__decap_3
XFILLER_50_15 VGND VGND VPWR VPWR sky130_fd_sc_hd__decap_8
Xclkload4 clknet_leaf_1_clk_10mhz VGND VGND VPWR VPWR clkload4/Y sky130_fd_sc_hd__clkinv_8
XPHY_EDGE_ROW_3_Left_67 VGND VGND VPWR VPWR sky130_fd_sc_hd__decap_3
XFILLER_34_309 VGND VGND VPWR VPWR sky130_fd_sc_hd__fill_2
XTAP_TAPCELL_ROW_29_323 VGND VPWR sky130_fd_sc_hd__tapvpwrvgnd_1
XFILLER_27_361 VPWR VGND VPWR VGND sky130_ef_sc_hd__decap_12
XFILLER_19_317 VPWR VGND VPWR VGND sky130_ef_sc_hd__decap_12
XTAP_TAPCELL_ROW_12_212 VGND VPWR sky130_fd_sc_hd__tapvpwrvgnd_1
X_1211_ net136 net47 _0282_ VGND VGND VPWR VPWR _0180_ sky130_fd_sc_hd__mux2_1
X_1142_ net30 net29 VGND VGND VPWR VPWR _0737_ sky130_fd_sc_hd__nor2_1
X_1073_ net220 net170 net14 VGND VGND VPWR VPWR _0077_ sky130_fd_sc_hd__mux2_1
XFILLER_33_353 VPWR VGND VPWR VGND sky130_ef_sc_hd__decap_12
XFILLER_18_361 VGND VGND VPWR VPWR sky130_fd_sc_hd__decap_3
X_0857_ u_srf_ctrl.state\[2\] u_srf_ctrl.state\[1\] _0517_ _0551_ VGND VGND VPWR VPWR
+ _0552_ sky130_fd_sc_hd__o31a_1
X_0926_ u_srf_ctrl.timer\[19\] u_srf_ctrl.state\[1\] _0596_ _0600_ _0467_ VGND VGND
+ VPWR VPWR _0601_ sky130_fd_sc_hd__a311o_1
Xhold27 u_fifo.mem\[10\]\[7\] VGND VGND VPWR VPWR net95 sky130_fd_sc_hd__dlygate4sd3_1
X_1409_ u_uart.clk_count\[3\] _0410_ u_uart.clk_count\[4\] VGND VGND VPWR VPWR _0414_
+ sky130_fd_sc_hd__a21oi_1
Xhold16 u_fifo.mem\[0\]\[6\] VGND VGND VPWR VPWR net84 sky130_fd_sc_hd__dlygate4sd3_1
Xhold38 u_fifo.mem\[4\]\[6\] VGND VGND VPWR VPWR net106 sky130_fd_sc_hd__dlygate4sd3_1
X_0788_ u_srf_ctrl.timer\[1\] u_srf_ctrl.timer\[0\] u_srf_ctrl.timer\[3\] u_srf_ctrl.timer\[2\]
+ VGND VGND VPWR VPWR _0503_ sky130_fd_sc_hd__or4_1
XFILLER_29_38 VPWR VGND VPWR VGND sky130_ef_sc_hd__decap_12
XFILLER_43_139 VGND VGND VPWR VPWR sky130_fd_sc_hd__fill_1
XFILLER_28_136 VGND VGND VPWR VPWR sky130_fd_sc_hd__decap_4
Xhold49 u_fifo.mem\[14\]\[0\] VGND VGND VPWR VPWR net117 sky130_fd_sc_hd__dlygate4sd3_1
XTAP_TAPCELL_ROW_26_304 VGND VPWR sky130_fd_sc_hd__tapvpwrvgnd_1
XFILLER_16_309 VGND VGND VPWR VPWR sky130_fd_sc_hd__decap_4
XFILLER_51_150 VGND VGND VPWR VPWR sky130_fd_sc_hd__fill_1
XFILLER_3_279 VGND VGND VPWR VPWR sky130_fd_sc_hd__fill_1
XFILLER_34_139 VGND VGND VPWR VPWR sky130_fd_sc_hd__fill_1
XFILLER_15_342 VPWR VGND VPWR VGND sky130_ef_sc_hd__decap_12
XFILLER_51_91 VPWR VGND VPWR VGND sky130_ef_sc_hd__decap_12
XTAP_TAPCELL_ROW_40_395 VGND VPWR sky130_fd_sc_hd__tapvpwrvgnd_1
X_1691_ clknet_leaf_25_clk_10mhz _0194_ VGND VGND VPWR VPWR u_fifo.mem\[1\]\[0\] sky130_fd_sc_hd__dfxtp_1
X_1760_ clknet_leaf_28_clk_10mhz _0263_ net54 VGND VGND VPWR VPWR u_srf_ctrl.echo_counter\[5\]
+ sky130_fd_sc_hd__dfrtp_4
XFILLER_32_3 VGND VGND VPWR VPWR sky130_fd_sc_hd__decap_8
X_1125_ net119 net49 _0734_ VGND VGND VPWR VPWR _0107_ sky130_fd_sc_hd__mux2_1
XTAP_TAPCELL_ROW_48_451 VGND VPWR sky130_fd_sc_hd__tapvpwrvgnd_1
XTAP_TAPCELL_ROW_31_340 VGND VPWR sky130_fd_sc_hd__tapvpwrvgnd_1
X_1056_ net219 net17 VGND VGND VPWR VPWR _0064_ sky130_fd_sc_hd__and2_1
X_0909_ _0588_ VGND VGND VPWR VPWR _0589_ sky130_fd_sc_hd__inv_2
XFILLER_0_249 VGND VGND VPWR VPWR sky130_fd_sc_hd__decap_3
XTAP_TAPCELL_ROW_54_487 VGND VPWR sky130_fd_sc_hd__tapvpwrvgnd_1
XFILLER_16_139 VGND VGND VPWR VPWR sky130_fd_sc_hd__fill_1
XPHY_EDGE_ROW_6_Left_70 VGND VGND VPWR VPWR sky130_fd_sc_hd__decap_3
XTAP_TAPCELL_ROW_45_432 VGND VPWR sky130_fd_sc_hd__tapvpwrvgnd_1
XFILLER_30_120 VGND VGND VPWR VPWR sky130_fd_sc_hd__decap_8
X_1743_ clknet_leaf_6_clk_10mhz _0246_ net63 VGND VGND VPWR VPWR u_uart.clk_count\[3\]
+ sky130_fd_sc_hd__dfrtp_1
X_1674_ clknet_leaf_13_clk_10mhz _0177_ VGND VGND VPWR VPWR u_fifo.mem\[3\]\[7\] sky130_fd_sc_hd__dfxtp_1
XFILLER_7_85 VGND VGND VPWR VPWR sky130_fd_sc_hd__decap_8
XFILLER_53_278 VGND VGND VPWR VPWR sky130_fd_sc_hd__fill_2
X_1039_ u_packet_assembler.timer\[12\] u_packet_assembler.timer\[11\] u_packet_assembler.timer\[10\]
+ _0691_ VGND VGND VPWR VPWR _0699_ sky130_fd_sc_hd__and4_1
X_1108_ _0718_ _0729_ VGND VGND VPWR VPWR _0731_ sky130_fd_sc_hd__and2_1
Xclkbuf_leaf_8_clk_10mhz clknet_2_1__leaf_clk_10mhz VGND VGND VPWR VPWR clknet_leaf_8_clk_10mhz
+ sky130_fd_sc_hd__clkbuf_8
XTAP_TAPCELL_ROW_51_468 VGND VPWR sky130_fd_sc_hd__tapvpwrvgnd_1
XFILLER_42_27 VGND VGND VPWR VPWR sky130_fd_sc_hd__fill_1
XFILLER_21_164 VGND VGND VPWR VPWR sky130_fd_sc_hd__decap_4
XFILLER_21_175 VGND VGND VPWR VPWR sky130_fd_sc_hd__fill_1
XFILLER_21_197 VGND VGND VPWR VPWR sky130_fd_sc_hd__decap_3
XTAP_TAPCELL_ROW_42_413 VGND VPWR sky130_fd_sc_hd__tapvpwrvgnd_1
XPHY_EDGE_ROW_32_Left_96 VGND VGND VPWR VPWR sky130_fd_sc_hd__decap_3
XFILLER_12_153 VGND VGND VPWR VPWR sky130_fd_sc_hd__decap_3
XFILLER_16_72 VPWR VGND VPWR VGND sky130_ef_sc_hd__decap_12
XFILLER_32_60 VGND VGND VPWR VPWR sky130_fd_sc_hd__fill_2
XFILLER_4_330 VPWR VGND VPWR VGND sky130_ef_sc_hd__decap_12
XFILLER_12_197 VGND VGND VPWR VPWR sky130_fd_sc_hd__decap_3
X_1390_ net216 _0494_ net14 VGND VGND VPWR VPWR _0242_ sky130_fd_sc_hd__a21o_1
XFILLER_35_278 VGND VGND VPWR VPWR sky130_fd_sc_hd__fill_2
Xhold157 u_uart.tx_data_reg\[2\] VGND VGND VPWR VPWR net225 sky130_fd_sc_hd__dlygate4sd3_1
Xhold102 fifo_dout\[0\] VGND VGND VPWR VPWR net170 sky130_fd_sc_hd__dlygate4sd3_1
Xhold146 fifo_dout\[3\] VGND VGND VPWR VPWR net214 sky130_fd_sc_hd__dlygate4sd3_1
X_1726_ clknet_leaf_8_clk_10mhz _0229_ VGND VGND VPWR VPWR u_fifo.mem\[13\]\[1\] sky130_fd_sc_hd__dfxtp_1
X_1657_ clknet_leaf_11_clk_10mhz _0160_ VGND VGND VPWR VPWR u_fifo.mem\[5\]\[6\] sky130_fd_sc_hd__dfxtp_1
Xhold135 u_fifo.mem\[15\]\[1\] VGND VGND VPWR VPWR net203 sky130_fd_sc_hd__dlygate4sd3_1
Xhold124 u_fifo.mem\[2\]\[6\] VGND VGND VPWR VPWR net192 sky130_fd_sc_hd__dlygate4sd3_1
Xhold113 u_fifo.mem\[6\]\[4\] VGND VGND VPWR VPWR net181 sky130_fd_sc_hd__dlygate4sd3_1
Xhold179 u_max30102_ctrl.clk_div\[7\] VGND VGND VPWR VPWR net247 sky130_fd_sc_hd__dlygate4sd3_1
Xhold168 distance_out\[0\] VGND VGND VPWR VPWR net236 sky130_fd_sc_hd__dlygate4sd3_1
X_1588_ clknet_leaf_24_clk_10mhz _0092_ net22 VGND VGND VPWR VPWR fifo_din\[6\] sky130_fd_sc_hd__dfrtp_1
XFILLER_5_138 VGND VGND VPWR VPWR sky130_fd_sc_hd__decap_8
XFILLER_5_116 VGND VGND VPWR VPWR sky130_fd_sc_hd__decap_4
XTAP_TAPCELL_ROW_4_160 VGND VPWR sky130_fd_sc_hd__tapvpwrvgnd_1
XFILLER_17_223 VGND VGND VPWR VPWR sky130_fd_sc_hd__fill_1
XFILLER_43_70 VGND VGND VPWR VPWR sky130_fd_sc_hd__fill_1
X_0890_ net9 _0574_ _0575_ net19 u_srf_ctrl.timer\[9\] VGND VGND VPWR VPWR _0031_
+ sky130_fd_sc_hd__a32o_1
X_1511_ clknet_leaf_4_clk_10mhz _0037_ net58 VGND VGND VPWR VPWR u_srf_ctrl.timer\[15\]
+ sky130_fd_sc_hd__dfrtp_1
X_1442_ net28 _0429_ VGND VGND VPWR VPWR _0433_ sky130_fd_sc_hd__nand2_1
X_1373_ net47 net199 _0394_ VGND VGND VPWR VPWR _0230_ sky130_fd_sc_hd__mux2_1
XTAP_TAPCELL_ROW_18_251 VGND VPWR sky130_fd_sc_hd__tapvpwrvgnd_1
XFILLER_23_237 VGND VGND VPWR VPWR sky130_fd_sc_hd__fill_1
XFILLER_48_26 VGND VGND VPWR VPWR sky130_fd_sc_hd__fill_2
X_1709_ clknet_leaf_9_clk_10mhz _0212_ net61 VGND VGND VPWR VPWR u_fifo.rd_ptr\[2\]
+ sky130_fd_sc_hd__dfrtp_1
XFILLER_39_370 VGND VGND VPWR VPWR sky130_fd_sc_hd__decap_6
XTAP_TAPCELL_ROW_1_141 VGND VPWR sky130_fd_sc_hd__tapvpwrvgnd_1
Xfanout63 net64 VGND VGND VPWR VPWR net63 sky130_fd_sc_hd__buf_2
Xfanout30 u_fifo.wr_ptr\[0\] VGND VGND VPWR VPWR net30 sky130_fd_sc_hd__buf_2
Xfanout52 net53 VGND VGND VPWR VPWR net52 sky130_fd_sc_hd__clkbuf_4
XFILLER_14_226 VGND VGND VPWR VPWR sky130_fd_sc_hd__decap_3
Xfanout41 fifo_din\[5\] VGND VGND VPWR VPWR net41 sky130_fd_sc_hd__buf_2
XFILLER_49_167 VGND VGND VPWR VPWR sky130_fd_sc_hd__fill_1
XFILLER_60_365 VPWR VGND VPWR VGND sky130_ef_sc_hd__decap_12
XFILLER_60_321 VPWR VGND VPWR VGND sky130_ef_sc_hd__decap_12
XFILLER_54_91 VGND VGND VPWR VPWR sky130_fd_sc_hd__fill_1
XFILLER_45_373 VGND VGND VPWR VPWR sky130_fd_sc_hd__decap_4
XTAP_TAPCELL_ROW_15_232 VGND VPWR sky130_fd_sc_hd__tapvpwrvgnd_1
XFILLER_62_3 VPWR VGND VPWR VGND sky130_ef_sc_hd__decap_12
Xclkload11 clknet_leaf_5_clk_10mhz VGND VGND VPWR VPWR clkload11/Y sky130_fd_sc_hd__bufinv_16
Xclkload22 clknet_leaf_10_clk_10mhz VGND VGND VPWR VPWR clkload22/Y sky130_fd_sc_hd__bufinv_16
X_0873_ u_srf_ctrl.timer\[4\] _0561_ VGND VGND VPWR VPWR _0564_ sky130_fd_sc_hd__nand2_1
XFILLER_9_285 VPWR VGND VPWR VGND sky130_ef_sc_hd__decap_12
XFILLER_13_281 VGND VGND VPWR VPWR sky130_fd_sc_hd__decap_3
XFILLER_13_292 VGND VGND VPWR VPWR sky130_fd_sc_hd__decap_6
X_0942_ _0609_ _0614_ VGND VGND VPWR VPWR _0616_ sky130_fd_sc_hd__nor2_1
X_1425_ u_uart.state\[1\] _0470_ VGND VGND VPWR VPWR _0420_ sky130_fd_sc_hd__or2_1
X_1287_ u_fifo.mem\[15\]\[0\] _0291_ _0298_ u_fifo.mem\[12\]\[0\] VGND VGND VPWR VPWR
+ _0319_ sky130_fd_sc_hd__a22o_1
X_1356_ u_fifo.mem\[4\]\[6\] _0311_ _0379_ _0381_ VGND VGND VPWR VPWR _0382_ sky130_fd_sc_hd__a211o_1
XFILLER_36_362 VGND VGND VPWR VPWR sky130_fd_sc_hd__fill_2
XFILLER_36_340 VGND VGND VPWR VPWR sky130_fd_sc_hd__fill_2
XFILLER_18_29 VPWR VGND VPWR VGND sky130_ef_sc_hd__decap_12
XFILLER_51_376 VGND VGND VPWR VPWR sky130_fd_sc_hd__fill_1
Xclkload5 clknet_leaf_25_clk_10mhz VGND VGND VPWR VPWR clkload5/Y sky130_fd_sc_hd__inv_6
XFILLER_59_69 VGND VGND VPWR VPWR sky130_fd_sc_hd__fill_2
XFILLER_19_329 VGND VGND VPWR VPWR sky130_fd_sc_hd__decap_6
XFILLER_61_107 VGND VGND VPWR VPWR sky130_fd_sc_hd__decap_4
XTAP_TAPCELL_ROW_29_324 VGND VPWR sky130_fd_sc_hd__tapvpwrvgnd_1
XFILLER_27_373 VGND VGND VPWR VPWR sky130_fd_sc_hd__decap_4
XFILLER_42_365 VPWR VGND VPWR VGND sky130_ef_sc_hd__decap_12
Xclkbuf_leaf_23_clk_10mhz clknet_2_2__leaf_clk_10mhz VGND VGND VPWR VPWR clknet_leaf_23_clk_10mhz
+ sky130_fd_sc_hd__clkbuf_8
XTAP_TAPCELL_ROW_12_213 VGND VPWR sky130_fd_sc_hd__tapvpwrvgnd_1
XFILLER_24_50 VPWR VGND VPWR VGND sky130_ef_sc_hd__decap_12
XFILLER_6_288 VGND VGND VPWR VPWR sky130_fd_sc_hd__decap_8
X_1072_ net36 net161 _0712_ VGND VGND VPWR VPWR _0076_ sky130_fd_sc_hd__mux2_1
X_1141_ net36 net193 _0736_ VGND VGND VPWR VPWR _0121_ sky130_fd_sc_hd__mux2_1
X_1210_ net114 net49 _0282_ VGND VGND VPWR VPWR _0179_ sky130_fd_sc_hd__mux2_1
XFILLER_37_104 VGND VGND VPWR VPWR sky130_fd_sc_hd__decap_8
XFILLER_33_365 VPWR VGND VPWR VGND sky130_ef_sc_hd__decap_12
X_0787_ _0498_ _0499_ _0500_ _0501_ VGND VGND VPWR VPWR _0502_ sky130_fd_sc_hd__or4_1
X_0856_ u_srf_ctrl.state\[1\] _0518_ VGND VGND VPWR VPWR _0551_ sky130_fd_sc_hd__or2_1
X_0925_ u_srf_ctrl.state\[1\] _0553_ VGND VGND VPWR VPWR _0600_ sky130_fd_sc_hd__nor2_1
Xhold39 u_fifo.mem\[0\]\[5\] VGND VGND VPWR VPWR net107 sky130_fd_sc_hd__dlygate4sd3_1
Xhold17 u_fifo.mem\[12\]\[7\] VGND VGND VPWR VPWR net85 sky130_fd_sc_hd__dlygate4sd3_1
X_1408_ u_uart.clk_count\[4\] u_uart.clk_count\[3\] _0410_ VGND VGND VPWR VPWR _0413_
+ sky130_fd_sc_hd__and3_1
Xhold28 u_fifo.mem\[10\]\[3\] VGND VGND VPWR VPWR net96 sky130_fd_sc_hd__dlygate4sd3_1
XFILLER_28_104 VGND VGND VPWR VPWR sky130_fd_sc_hd__fill_1
X_1339_ u_fifo.mem\[8\]\[5\] _0300_ _0312_ u_fifo.mem\[13\]\[5\] _0365_ VGND VGND
+ VPWR VPWR _0366_ sky130_fd_sc_hd__a221o_1
XTAP_TAPCELL_ROW_26_305 VGND VPWR sky130_fd_sc_hd__tapvpwrvgnd_1
XFILLER_61_15 VPWR VGND VPWR VGND sky130_ef_sc_hd__decap_12
XFILLER_51_140 VGND VGND VPWR VPWR sky130_fd_sc_hd__fill_1
XTAP_TAPCELL_ROW_34_360 VGND VPWR sky130_fd_sc_hd__tapvpwrvgnd_1
XFILLER_24_365 VPWR VGND VPWR VGND sky130_ef_sc_hd__decap_12
XFILLER_3_269 VGND VGND VPWR VPWR sky130_fd_sc_hd__fill_2
XFILLER_3_225 VPWR VGND VPWR VGND sky130_ef_sc_hd__decap_12
XFILLER_10_41 VPWR VGND VPWR VGND sky130_ef_sc_hd__decap_12
XFILLER_10_85 VPWR VGND VPWR VGND sky130_ef_sc_hd__decap_12
XFILLER_59_240 VGND VGND VPWR VPWR sky130_fd_sc_hd__decap_3
XFILLER_19_94 VPWR VGND VPWR VGND sky130_ef_sc_hd__decap_12
XFILLER_42_195 VGND VGND VPWR VPWR sky130_fd_sc_hd__fill_1
XFILLER_35_71 VGND VGND VPWR VPWR sky130_fd_sc_hd__decap_4
XFILLER_15_354 VPWR VGND VPWR VGND sky130_ef_sc_hd__decap_12
XFILLER_51_70 VGND VGND VPWR VPWR sky130_fd_sc_hd__fill_1
X_1690_ clknet_leaf_16_clk_10mhz _0193_ VGND VGND VPWR VPWR u_fifo.mem\[2\]\[7\] sky130_fd_sc_hd__dfxtp_1
XTAP_TAPCELL_ROW_40_396 VGND VPWR sky130_fd_sc_hd__tapvpwrvgnd_1
XFILLER_25_3 VGND VGND VPWR VPWR sky130_fd_sc_hd__decap_8
X_1124_ net158 net50 _0734_ VGND VGND VPWR VPWR _0106_ sky130_fd_sc_hd__mux2_1
XTAP_TAPCELL_ROW_48_452 VGND VPWR sky130_fd_sc_hd__tapvpwrvgnd_1
X_1055_ net210 net17 VGND VGND VPWR VPWR _0063_ sky130_fd_sc_hd__and2_1
XTAP_TAPCELL_ROW_31_341 VGND VPWR sky130_fd_sc_hd__tapvpwrvgnd_1
XFILLER_21_335 VGND VGND VPWR VPWR sky130_fd_sc_hd__fill_1
X_0908_ u_srf_ctrl.timer\[15\] u_srf_ctrl.timer\[14\] u_srf_ctrl.timer\[13\] _0579_
+ VGND VGND VPWR VPWR _0588_ sky130_fd_sc_hd__and4_1
X_0839_ _0538_ _0539_ VGND VGND VPWR VPWR _0007_ sky130_fd_sc_hd__nor2_1
XFILLER_56_15 VGND VGND VPWR VPWR sky130_fd_sc_hd__decap_6
XTAP_TAPCELL_ROW_54_488 VGND VPWR sky130_fd_sc_hd__tapvpwrvgnd_1
XFILLER_16_129 VGND VGND VPWR VPWR sky130_fd_sc_hd__fill_1
XFILLER_12_346 VPWR VGND VPWR VGND sky130_ef_sc_hd__decap_12
XFILLER_30_187 VGND VGND VPWR VPWR sky130_fd_sc_hd__fill_1
Xclkbuf_2_2__f_clk_10mhz clknet_0_clk_10mhz VGND VGND VPWR VPWR clknet_2_2__leaf_clk_10mhz
+ sky130_fd_sc_hd__clkbuf_16
X_1742_ clknet_leaf_6_clk_10mhz _0245_ net63 VGND VGND VPWR VPWR u_uart.clk_count\[2\]
+ sky130_fd_sc_hd__dfrtp_1
X_1673_ clknet_leaf_16_clk_10mhz _0176_ VGND VGND VPWR VPWR u_fifo.mem\[3\]\[6\] sky130_fd_sc_hd__dfxtp_1
XFILLER_7_53 VGND VGND VPWR VPWR sky130_fd_sc_hd__decap_3
XFILLER_7_350 VPWR VGND VPWR VGND sky130_ef_sc_hd__decap_12
XFILLER_38_287 VGND VGND VPWR VPWR sky130_fd_sc_hd__decap_8
XPHY_EDGE_ROW_5_Right_5 VGND VGND VPWR VPWR sky130_fd_sc_hd__decap_3
X_1038_ u_packet_assembler.timer\[12\] _0696_ VGND VGND VPWR VPWR _0698_ sky130_fd_sc_hd__or2_1
X_1107_ _0729_ VGND VGND VPWR VPWR _0730_ sky130_fd_sc_hd__inv_2
XTAP_TAPCELL_ROW_51_469 VGND VPWR sky130_fd_sc_hd__tapvpwrvgnd_1
XFILLER_21_154 VGND VGND VPWR VPWR sky130_fd_sc_hd__decap_3
XFILLER_29_221 VGND VGND VPWR VPWR sky130_fd_sc_hd__decap_3
XFILLER_59_9 VGND VGND VPWR VPWR sky130_fd_sc_hd__fill_1
XFILLER_4_342 VPWR VGND VPWR VGND sky130_ef_sc_hd__decap_12
XTAP_TAPCELL_ROW_7_180 VGND VPWR sky130_fd_sc_hd__tapvpwrvgnd_1
X_1725_ clknet_leaf_13_clk_10mhz _0228_ VGND VGND VPWR VPWR u_fifo.mem\[13\]\[0\]
+ sky130_fd_sc_hd__dfxtp_1
X_1656_ clknet_leaf_8_clk_10mhz _0159_ VGND VGND VPWR VPWR u_fifo.mem\[5\]\[5\] sky130_fd_sc_hd__dfxtp_1
Xhold136 fifo_dout\[7\] VGND VGND VPWR VPWR net204 sky130_fd_sc_hd__dlygate4sd3_1
Xhold114 u_fifo.mem\[13\]\[0\] VGND VGND VPWR VPWR net182 sky130_fd_sc_hd__dlygate4sd3_1
Xhold103 u_fifo.mem\[10\]\[2\] VGND VGND VPWR VPWR net171 sky130_fd_sc_hd__dlygate4sd3_1
Xhold125 u_fifo.mem\[9\]\[7\] VGND VGND VPWR VPWR net193 sky130_fd_sc_hd__dlygate4sd3_1
Xhold158 u_uart.clk_count\[11\] VGND VGND VPWR VPWR net226 sky130_fd_sc_hd__dlygate4sd3_1
Xhold147 u_fifo.mem\[9\]\[1\] VGND VGND VPWR VPWR net215 sky130_fd_sc_hd__dlygate4sd3_1
Xhold169 distance_out\[4\] VGND VGND VPWR VPWR net237 sky130_fd_sc_hd__dlygate4sd3_1
X_1587_ clknet_leaf_25_clk_10mhz _0091_ net21 VGND VGND VPWR VPWR fifo_din\[5\] sky130_fd_sc_hd__dfrtp_1
XFILLER_37_28 VGND VGND VPWR VPWR sky130_fd_sc_hd__fill_1
XFILLER_26_213 VGND VGND VPWR VPWR sky130_fd_sc_hd__decap_3
XFILLER_26_279 VGND VGND VPWR VPWR sky130_fd_sc_hd__decap_6
XFILLER_27_61 VGND VGND VPWR VPWR sky130_fd_sc_hd__decap_4
XTAP_TAPCELL_ROW_4_161 VGND VPWR sky130_fd_sc_hd__tapvpwrvgnd_1
XFILLER_32_249 VGND VGND VPWR VPWR sky130_fd_sc_hd__decap_3
X_1510_ clknet_leaf_4_clk_10mhz _0036_ net58 VGND VGND VPWR VPWR u_srf_ctrl.timer\[14\]
+ sky130_fd_sc_hd__dfrtp_2
XFILLER_4_161 VGND VGND VPWR VPWR sky130_fd_sc_hd__fill_2
X_1441_ net28 _0429_ VGND VGND VPWR VPWR _0432_ sky130_fd_sc_hd__or2_1
X_1372_ net49 net213 _0394_ VGND VGND VPWR VPWR _0229_ sky130_fd_sc_hd__mux2_1
XFILLER_48_360 VGND VGND VPWR VPWR sky130_fd_sc_hd__decap_4
XTAP_TAPCELL_ROW_61_531 VGND VPWR sky130_fd_sc_hd__tapvpwrvgnd_1
XTAP_TAPCELL_ROW_18_252 VGND VPWR sky130_fd_sc_hd__tapvpwrvgnd_1
X_1708_ clknet_leaf_9_clk_10mhz _0211_ net61 VGND VGND VPWR VPWR u_fifo.rd_ptr\[1\]
+ sky130_fd_sc_hd__dfrtp_1
XFILLER_2_109 VPWR VGND VPWR VGND sky130_ef_sc_hd__decap_12
X_1639_ clknet_leaf_13_clk_10mhz _0142_ VGND VGND VPWR VPWR u_fifo.mem\[7\]\[4\] sky130_fd_sc_hd__dfxtp_1
XFILLER_54_341 VPWR VGND VPWR VGND sky130_ef_sc_hd__decap_12
XTAP_TAPCELL_ROW_1_142 VGND VPWR sky130_fd_sc_hd__tapvpwrvgnd_1
Xfanout64 net65 VGND VGND VPWR VPWR net64 sky130_fd_sc_hd__clkbuf_4
Xfanout31 net32 VGND VGND VPWR VPWR net31 sky130_fd_sc_hd__clkbuf_2
Xfanout20 net22 VGND VGND VPWR VPWR net20 sky130_fd_sc_hd__clkbuf_4
Xfanout53 net65 VGND VGND VPWR VPWR net53 sky130_fd_sc_hd__clkbuf_4
Xfanout42 fifo_din\[4\] VGND VGND VPWR VPWR net42 sky130_fd_sc_hd__buf_2
XFILLER_1_131 VGND VGND VPWR VPWR sky130_fd_sc_hd__fill_1
XFILLER_38_93 VGND VGND VPWR VPWR sky130_fd_sc_hd__fill_2
XFILLER_60_333 VPWR VGND VPWR VGND sky130_ef_sc_hd__decap_12
X_0941_ _0609_ _0614_ VGND VGND VPWR VPWR _0615_ sky130_fd_sc_hd__nand2_1
XTAP_TAPCELL_ROW_15_233 VGND VPWR sky130_fd_sc_hd__tapvpwrvgnd_1
Xclkload12 clknet_leaf_6_clk_10mhz VGND VGND VPWR VPWR clkload12/Y sky130_fd_sc_hd__inv_8
Xclkload23 clknet_leaf_11_clk_10mhz VGND VGND VPWR VPWR clkload23/Y sky130_fd_sc_hd__bufinv_16
XFILLER_9_297 VPWR VGND VPWR VGND sky130_ef_sc_hd__decap_12
X_0872_ u_srf_ctrl.state\[2\] _0486_ _0476_ VGND VGND VPWR VPWR _0563_ sky130_fd_sc_hd__o21ai_1
X_1424_ u_uart.tx_data_reg\[0\] u_uart.tx_data_reg\[1\] u_uart.tx_data_reg\[2\] u_uart.tx_data_reg\[3\]
+ u_uart.bit_index\[0\] u_uart.bit_index\[1\] VGND VGND VPWR VPWR _0419_ sky130_fd_sc_hd__mux4_1
X_1355_ u_fifo.mem\[10\]\[6\] _0307_ _0310_ u_fifo.mem\[11\]\[6\] _0380_ VGND VGND
+ VPWR VPWR _0381_ sky130_fd_sc_hd__a221o_1
X_1286_ u_fifo.mem\[1\]\[0\] _0302_ _0310_ u_fifo.mem\[11\]\[0\] VGND VGND VPWR VPWR
+ _0318_ sky130_fd_sc_hd__a22o_1
XFILLER_34_29 VGND VGND VPWR VPWR sky130_fd_sc_hd__fill_2
Xclkload6 clknet_leaf_26_clk_10mhz VGND VGND VPWR VPWR clkload6/Y sky130_fd_sc_hd__clkinv_2
XFILLER_46_105 VGND VGND VPWR VPWR sky130_fd_sc_hd__decap_6
XTAP_TAPCELL_ROW_29_325 VGND VPWR sky130_fd_sc_hd__tapvpwrvgnd_1
XFILLER_42_355 VGND VGND VPWR VPWR sky130_fd_sc_hd__decap_8
XTAP_TAPCELL_ROW_37_380 VGND VPWR sky130_fd_sc_hd__tapvpwrvgnd_1
XFILLER_6_234 VGND VGND VPWR VPWR sky130_fd_sc_hd__decap_3
XTAP_TAPCELL_ROW_12_214 VGND VPWR sky130_fd_sc_hd__tapvpwrvgnd_1
XFILLER_24_62 VGND VGND VPWR VPWR sky130_fd_sc_hd__fill_1
Xclkbuf_leaf_27_clk_10mhz clknet_2_0__leaf_clk_10mhz VGND VGND VPWR VPWR clknet_leaf_27_clk_10mhz
+ sky130_fd_sc_hd__clkbuf_8
XFILLER_27_7 VGND VGND VPWR VPWR sky130_fd_sc_hd__decap_6
X_1071_ net38 net176 _0712_ VGND VGND VPWR VPWR _0075_ sky130_fd_sc_hd__mux2_1
X_1140_ net38 net156 _0736_ VGND VGND VPWR VPWR _0120_ sky130_fd_sc_hd__mux2_1
XFILLER_1_55 VGND VGND VPWR VPWR sky130_fd_sc_hd__fill_1
XFILLER_18_341 VPWR VGND VPWR VGND sky130_ef_sc_hd__decap_12
XFILLER_60_141 VGND VGND VPWR VPWR sky130_fd_sc_hd__decap_6
X_0924_ net9 _0598_ _0599_ net19 u_srf_ctrl.timer\[19\] VGND VGND VPWR VPWR _0041_
+ sky130_fd_sc_hd__a32o_1
X_0786_ u_srf_ctrl.echo_counter\[15\] u_srf_ctrl.echo_counter\[11\] u_srf_ctrl.echo_counter\[1\]
+ u_srf_ctrl.echo_counter\[0\] VGND VGND VPWR VPWR _0501_ sky130_fd_sc_hd__or4_1
X_0855_ u_srf_ctrl.state\[1\] _0518_ VGND VGND VPWR VPWR _0550_ sky130_fd_sc_hd__nor2_2
Xhold18 u_fifo.mem\[8\]\[5\] VGND VGND VPWR VPWR net86 sky130_fd_sc_hd__dlygate4sd3_1
X_1338_ u_fifo.mem\[12\]\[5\] _0298_ _0308_ u_fifo.mem\[5\]\[5\] VGND VGND VPWR VPWR
+ _0365_ sky130_fd_sc_hd__a22o_1
X_1407_ net253 _0410_ _0412_ VGND VGND VPWR VPWR _0246_ sky130_fd_sc_hd__a21oi_1
Xhold29 u_fifo.mem\[14\]\[5\] VGND VGND VPWR VPWR net97 sky130_fd_sc_hd__dlygate4sd3_1
X_1269_ net33 net31 net35 VGND VGND VPWR VPWR _0301_ sky130_fd_sc_hd__or3b_2
XTAP_TAPCELL_ROW_26_306 VGND VPWR sky130_fd_sc_hd__tapvpwrvgnd_1
XFILLER_61_27 VPWR VGND VPWR VGND sky130_ef_sc_hd__decap_12
XTAP_TAPCELL_ROW_34_361 VGND VPWR sky130_fd_sc_hd__tapvpwrvgnd_1
XFILLER_3_237 VPWR VGND VPWR VGND sky130_ef_sc_hd__decap_12
XFILLER_10_53 VPWR VGND VPWR VGND sky130_ef_sc_hd__decap_12
XFILLER_19_62 VGND VGND VPWR VPWR sky130_fd_sc_hd__fill_1
XFILLER_19_73 VGND VGND VPWR VPWR sky130_fd_sc_hd__fill_1
XFILLER_42_141 VGND VGND VPWR VPWR sky130_fd_sc_hd__fill_1
XFILLER_30_325 VGND VGND VPWR VPWR sky130_fd_sc_hd__fill_1
XFILLER_15_366 VGND VGND VPWR VPWR sky130_fd_sc_hd__decap_8
XTAP_TAPCELL_ROW_40_397 VGND VPWR sky130_fd_sc_hd__tapvpwrvgnd_1
XFILLER_18_3 VPWR VGND VPWR VGND sky130_ef_sc_hd__decap_12
XFILLER_33_152 VGND VGND VPWR VPWR sky130_fd_sc_hd__decap_3
X_1123_ net30 net29 _0709_ _0732_ VGND VGND VPWR VPWR _0734_ sky130_fd_sc_hd__and4b_4
X_1054_ net205 net17 VGND VGND VPWR VPWR _0062_ sky130_fd_sc_hd__and2_1
X_0907_ u_srf_ctrl.timer\[15\] _0585_ VGND VGND VPWR VPWR _0587_ sky130_fd_sc_hd__or2_1
X_0838_ net281 _0536_ net244 VGND VGND VPWR VPWR _0539_ sky130_fd_sc_hd__a21oi_1
X_0769_ _0469_ _0486_ VGND VGND VPWR VPWR _0000_ sky130_fd_sc_hd__nand2_1
XFILLER_56_27 VGND VGND VPWR VPWR sky130_fd_sc_hd__fill_1
XTAP_TAPCELL_ROW_54_489 VGND VPWR sky130_fd_sc_hd__tapvpwrvgnd_1
XFILLER_12_358 VGND VGND VPWR VPWR sky130_fd_sc_hd__decap_6
XFILLER_47_222 VGND VGND VPWR VPWR sky130_fd_sc_hd__fill_2
X_1741_ clknet_leaf_6_clk_10mhz _0244_ net63 VGND VGND VPWR VPWR u_uart.clk_count\[1\]
+ sky130_fd_sc_hd__dfrtp_1
X_1672_ clknet_leaf_17_clk_10mhz _0175_ VGND VGND VPWR VPWR u_fifo.mem\[3\]\[5\] sky130_fd_sc_hd__dfxtp_1
XFILLER_7_362 VPWR VGND VPWR VGND sky130_ef_sc_hd__decap_12
X_1106_ _0544_ _0549_ net13 VGND VGND VPWR VPWR _0729_ sky130_fd_sc_hd__a21oi_2
XFILLER_53_225 VGND VGND VPWR VPWR sky130_fd_sc_hd__fill_2
XFILLER_42_29 VGND VGND VPWR VPWR sky130_fd_sc_hd__decap_6
X_1037_ net12 _0695_ _0697_ net16 net263 VGND VGND VPWR VPWR _0056_ sky130_fd_sc_hd__a32o_1
XFILLER_44_247 VGND VGND VPWR VPWR sky130_fd_sc_hd__decap_4
XFILLER_32_40 VPWR VGND VPWR VGND sky130_ef_sc_hd__decap_12
XPHY_EDGE_ROW_11_Right_11 VGND VGND VPWR VPWR sky130_fd_sc_hd__decap_3
XFILLER_16_85 VPWR VGND VPWR VGND sky130_ef_sc_hd__decap_12
XFILLER_4_365 VPWR VGND VPWR VGND sky130_ef_sc_hd__decap_12
XFILLER_4_354 VGND VGND VPWR VPWR sky130_fd_sc_hd__decap_8
XPHY_EDGE_ROW_20_Right_20 VGND VGND VPWR VPWR sky130_fd_sc_hd__decap_3
XTAP_TAPCELL_ROW_7_181 VGND VPWR sky130_fd_sc_hd__tapvpwrvgnd_1
Xhold126 u_fifo.mem\[13\]\[7\] VGND VGND VPWR VPWR net194 sky130_fd_sc_hd__dlygate4sd3_1
Xhold115 u_fifo.mem\[5\]\[0\] VGND VGND VPWR VPWR net183 sky130_fd_sc_hd__dlygate4sd3_1
X_1724_ clknet_leaf_7_clk_10mhz _0227_ VGND VGND VPWR VPWR fifo_dout\[7\] sky130_fd_sc_hd__dfxtp_1
Xhold104 u_fifo.mem\[11\]\[1\] VGND VGND VPWR VPWR net172 sky130_fd_sc_hd__dlygate4sd3_1
Xhold148 u_uart.busy VGND VGND VPWR VPWR net216 sky130_fd_sc_hd__dlygate4sd3_1
X_1655_ clknet_leaf_12_clk_10mhz _0158_ VGND VGND VPWR VPWR u_fifo.mem\[5\]\[4\] sky130_fd_sc_hd__dfxtp_1
XFILLER_58_306 VGND VGND VPWR VPWR sky130_fd_sc_hd__fill_2
Xhold159 u_uart.clk_count\[8\] VGND VGND VPWR VPWR net227 sky130_fd_sc_hd__dlygate4sd3_1
Xhold137 u_packet_assembler.timer\[17\] VGND VGND VPWR VPWR net205 sky130_fd_sc_hd__dlygate4sd3_1
X_1586_ clknet_leaf_24_clk_10mhz _0090_ net21 VGND VGND VPWR VPWR fifo_din\[4\] sky130_fd_sc_hd__dfrtp_1
XFILLER_57_361 VPWR VGND VPWR VGND sky130_ef_sc_hd__decap_12
XFILLER_49_306 VGND VGND VPWR VPWR sky130_fd_sc_hd__decap_8
XTAP_TAPCELL_ROW_4_162 VGND VPWR sky130_fd_sc_hd__tapvpwrvgnd_1
XFILLER_1_335 VGND VGND VPWR VPWR sky130_fd_sc_hd__fill_1
XFILLER_17_225 VGND VGND VPWR VPWR sky130_fd_sc_hd__fill_1
XFILLER_40_294 VPWR VGND VPWR VGND sky130_ef_sc_hd__decap_12
X_1371_ net51 net182 _0394_ VGND VGND VPWR VPWR _0228_ sky130_fd_sc_hd__mux2_1
XFILLER_4_195 VGND VGND VPWR VPWR sky130_fd_sc_hd__fill_1
X_1440_ net15 _0430_ _0431_ _0427_ u_srf_ctrl.echo_counter\[2\] VGND VGND VPWR VPWR
+ _0260_ sky130_fd_sc_hd__a32o_1
XTAP_TAPCELL_ROW_61_532 VGND VPWR sky130_fd_sc_hd__tapvpwrvgnd_1
XFILLER_31_261 VGND VGND VPWR VPWR sky130_fd_sc_hd__decap_6
XTAP_TAPCELL_ROW_18_253 VGND VPWR sky130_fd_sc_hd__tapvpwrvgnd_1
X_1638_ clknet_leaf_13_clk_10mhz _0141_ VGND VGND VPWR VPWR u_fifo.mem\[7\]\[3\] sky130_fd_sc_hd__dfxtp_1
X_1707_ clknet_leaf_3_clk_10mhz _0210_ net61 VGND VGND VPWR VPWR u_fifo.rd_ptr\[0\]
+ sky130_fd_sc_hd__dfrtp_1
X_1569_ clknet_leaf_9_clk_10mhz _0077_ net64 VGND VGND VPWR VPWR u_uart.tx_data_reg\[0\]
+ sky130_fd_sc_hd__dfrtp_1
XFILLER_46_309 VGND VGND VPWR VPWR sky130_fd_sc_hd__decap_3
XFILLER_54_353 VGND VGND VPWR VPWR sky130_fd_sc_hd__decap_8
Xfanout10 _0563_ VGND VGND VPWR VPWR net10 sky130_fd_sc_hd__clkbuf_2
XTAP_TAPCELL_ROW_1_143 VGND VPWR sky130_fd_sc_hd__tapvpwrvgnd_1
Xfanout21 net22 VGND VGND VPWR VPWR net21 sky130_fd_sc_hd__clkbuf_4
Xfanout65 net1 VGND VGND VPWR VPWR net65 sky130_fd_sc_hd__buf_2
Xfanout43 fifo_din\[4\] VGND VGND VPWR VPWR net43 sky130_fd_sc_hd__clkbuf_2
Xfanout32 u_fifo.rd_ptr\[2\] VGND VGND VPWR VPWR net32 sky130_fd_sc_hd__clkbuf_2
Xfanout54 net57 VGND VGND VPWR VPWR net54 sky130_fd_sc_hd__clkbuf_4
XFILLER_22_250 VGND VGND VPWR VPWR sky130_fd_sc_hd__fill_2
XFILLER_49_169 VGND VGND VPWR VPWR sky130_fd_sc_hd__fill_2
XFILLER_38_83 VGND VGND VPWR VPWR sky130_fd_sc_hd__fill_1
XFILLER_60_345 VPWR VGND VPWR VGND sky130_ef_sc_hd__decap_12
XTAP_TAPCELL_ROW_15_234 VGND VPWR sky130_fd_sc_hd__tapvpwrvgnd_1
X_0940_ u_srf_ctrl.echo_counter\[9\] u_srf_ctrl.echo_counter\[5\] VGND VGND VPWR VPWR
+ _0614_ sky130_fd_sc_hd__xnor2_1
Xclkload24 clknet_leaf_12_clk_10mhz VGND VGND VPWR VPWR clkload24/Y sky130_fd_sc_hd__clkinvlp_4
Xclkload13 clknet_leaf_7_clk_10mhz VGND VGND VPWR VPWR clkload13/Y sky130_fd_sc_hd__bufinv_16
XPHY_EDGE_ROW_41_Left_105 VGND VGND VPWR VPWR sky130_fd_sc_hd__decap_3
X_0871_ _0552_ _0562_ VGND VGND VPWR VPWR _0025_ sky130_fd_sc_hd__and2_1
X_1285_ u_fifo.mem\[8\]\[0\] _0300_ _0312_ u_fifo.mem\[13\]\[0\] _0316_ VGND VGND
+ VPWR VPWR _0317_ sky130_fd_sc_hd__a221o_1
XFILLER_55_106 VGND VGND VPWR VPWR sky130_fd_sc_hd__decap_6
X_1423_ u_uart.state\[1\] _0470_ VGND VGND VPWR VPWR _0418_ sky130_fd_sc_hd__nand2_1
XPHY_EDGE_ROW_50_Left_114 VGND VGND VPWR VPWR sky130_fd_sc_hd__decap_3
XFILLER_48_3 VGND VGND VPWR VPWR sky130_fd_sc_hd__decap_3
X_1354_ u_fifo.mem\[14\]\[6\] _0306_ _0313_ u_fifo.mem\[3\]\[6\] VGND VGND VPWR VPWR
+ _0380_ sky130_fd_sc_hd__a22o_1
XFILLER_63_194 VGND VGND VPWR VPWR sky130_fd_sc_hd__fill_2
XFILLER_63_161 VGND VGND VPWR VPWR sky130_fd_sc_hd__decap_6
XFILLER_34_19 VGND VGND VPWR VPWR sky130_fd_sc_hd__fill_1
Xclkload7 clknet_leaf_27_clk_10mhz VGND VGND VPWR VPWR clkload7/Y sky130_fd_sc_hd__inv_6
XFILLER_46_139 VGND VGND VPWR VPWR sky130_fd_sc_hd__fill_1
XFILLER_39_180 VGND VGND VPWR VPWR sky130_fd_sc_hd__fill_1
XTAP_TAPCELL_ROW_29_326 VGND VPWR sky130_fd_sc_hd__tapvpwrvgnd_1
XFILLER_54_194 VGND VGND VPWR VPWR sky130_fd_sc_hd__fill_2
XFILLER_42_323 VGND VGND VPWR VPWR sky130_fd_sc_hd__decap_8
XTAP_TAPCELL_ROW_12_215 VGND VPWR sky130_fd_sc_hd__tapvpwrvgnd_1
XFILLER_24_41 VGND VGND VPWR VPWR sky130_fd_sc_hd__fill_1
XTAP_TAPCELL_ROW_20_270 VGND VPWR sky130_fd_sc_hd__tapvpwrvgnd_1
XFILLER_45_194 VPWR VGND VPWR VGND sky130_ef_sc_hd__decap_12
X_1070_ net41 net155 _0712_ VGND VGND VPWR VPWR _0074_ sky130_fd_sc_hd__mux2_1
XFILLER_33_323 VGND VGND VPWR VPWR sky130_fd_sc_hd__decap_4
XFILLER_18_353 VGND VGND VPWR VPWR sky130_fd_sc_hd__decap_8
X_0923_ u_srf_ctrl.timer\[19\] _0596_ VGND VGND VPWR VPWR _0599_ sky130_fd_sc_hd__nand2_1
X_0854_ _0544_ _0549_ VGND VGND VPWR VPWR _0021_ sky130_fd_sc_hd__and2b_2
XPHY_EDGE_ROW_49_Right_49 VGND VGND VPWR VPWR sky130_fd_sc_hd__decap_3
X_0785_ u_srf_ctrl.echo_counter\[14\] u_srf_ctrl.echo_counter\[13\] u_srf_ctrl.echo_counter\[12\]
+ u_srf_ctrl.echo_counter\[10\] VGND VGND VPWR VPWR _0500_ sky130_fd_sc_hd__or4_1
XPHY_EDGE_ROW_58_Right_58 VGND VGND VPWR VPWR sky130_fd_sc_hd__decap_3
X_1406_ u_uart.clk_count\[3\] _0410_ _0405_ VGND VGND VPWR VPWR _0412_ sky130_fd_sc_hd__o21ai_1
Xhold19 u_fifo.mem\[12\]\[6\] VGND VGND VPWR VPWR net87 sky130_fd_sc_hd__dlygate4sd3_1
X_1268_ net33 _0299_ VGND VGND VPWR VPWR _0300_ sky130_fd_sc_hd__nor2_4
X_1337_ net26 u_fifo.mem\[2\]\[5\] _0303_ VGND VGND VPWR VPWR _0364_ sky130_fd_sc_hd__o21ba_1
XFILLER_61_39 VPWR VGND VPWR VGND sky130_ef_sc_hd__decap_12
XFILLER_36_194 VGND VGND VPWR VPWR sky130_fd_sc_hd__fill_2
X_1199_ net30 u_fifo.wr_ptr\[1\] net56 net11 VGND VGND VPWR VPWR _0281_ sky130_fd_sc_hd__and4_4
XTAP_TAPCELL_ROW_26_307 VGND VPWR sky130_fd_sc_hd__tapvpwrvgnd_1
XFILLER_3_205 VPWR VGND VPWR VGND sky130_ef_sc_hd__decap_12
XFILLER_3_249 VPWR VGND VPWR VGND sky130_ef_sc_hd__decap_12
XFILLER_10_65 VPWR VGND VPWR VGND sky130_ef_sc_hd__decap_12
XFILLER_59_297 VGND VGND VPWR VPWR sky130_fd_sc_hd__decap_6
XFILLER_35_51 VGND VGND VPWR VPWR sky130_fd_sc_hd__decap_4
XFILLER_15_323 VGND VGND VPWR VPWR sky130_fd_sc_hd__decap_4
XFILLER_19_52 VGND VGND VPWR VPWR sky130_fd_sc_hd__fill_1
XFILLER_19_106 VGND VGND VPWR VPWR sky130_fd_sc_hd__decap_6
XFILLER_19_117 VPWR VGND VPWR VGND sky130_ef_sc_hd__decap_12
XFILLER_30_304 VGND VGND VPWR VPWR sky130_fd_sc_hd__decap_4
XTAP_TAPCELL_ROW_40_398 VGND VPWR sky130_fd_sc_hd__tapvpwrvgnd_1
X_1122_ net37 net195 _0733_ VGND VGND VPWR VPWR _0105_ sky130_fd_sc_hd__mux2_1
X_1053_ net242 _0707_ _0708_ u_packet_assembler.timer\[15\] VGND VGND VPWR VPWR _0061_
+ sky130_fd_sc_hd__a22o_1
XFILLER_21_337 VPWR VGND VPWR VGND sky130_ef_sc_hd__decap_12
X_0906_ net10 _0584_ _0586_ _0554_ net274 VGND VGND VPWR VPWR _0036_ sky130_fd_sc_hd__a32o_1
X_0837_ u_max30102_ctrl.clk_div\[11\] u_max30102_ctrl.clk_div\[10\] _0536_ VGND VGND
+ VPWR VPWR _0538_ sky130_fd_sc_hd__and3_1
X_0768_ net264 _0485_ VGND VGND VPWR VPWR _0486_ sky130_fd_sc_hd__nand2_1
XFILLER_21_53 VGND VGND VPWR VPWR sky130_fd_sc_hd__decap_3
XFILLER_62_248 VGND VGND VPWR VPWR sky130_fd_sc_hd__decap_4
XFILLER_47_289 VGND VGND VPWR VPWR sky130_fd_sc_hd__decap_4
XFILLER_47_278 VGND VGND VPWR VPWR sky130_fd_sc_hd__fill_2
XFILLER_62_93 VGND VGND VPWR VPWR sky130_fd_sc_hd__fill_2
X_1740_ clknet_leaf_7_clk_10mhz _0243_ net63 VGND VGND VPWR VPWR u_uart.clk_count\[0\]
+ sky130_fd_sc_hd__dfrtp_1
X_1671_ clknet_leaf_13_clk_10mhz _0174_ VGND VGND VPWR VPWR u_fifo.mem\[3\]\[4\] sky130_fd_sc_hd__dfxtp_1
XFILLER_7_374 VGND VGND VPWR VPWR sky130_fd_sc_hd__decap_3
XFILLER_30_3 VPWR VGND VPWR VGND sky130_ef_sc_hd__decap_12
X_1105_ net37 _0021_ _0717_ VGND VGND VPWR VPWR _0093_ sky130_fd_sc_hd__o21a_1
XFILLER_42_19 VGND VGND VPWR VPWR sky130_fd_sc_hd__decap_8
X_1036_ _0696_ VGND VGND VPWR VPWR _0697_ sky130_fd_sc_hd__inv_2
XFILLER_21_101 VGND VGND VPWR VPWR sky130_fd_sc_hd__decap_8
XFILLER_29_212 VGND VGND VPWR VPWR sky130_fd_sc_hd__fill_1
XFILLER_29_289 VGND VGND VPWR VPWR sky130_fd_sc_hd__decap_6
XFILLER_29_267 VGND VGND VPWR VPWR sky130_fd_sc_hd__decap_3
XTAP_TAPCELL_ROW_50_460 VGND VPWR sky130_fd_sc_hd__tapvpwrvgnd_1
XFILLER_32_52 VGND VGND VPWR VPWR sky130_fd_sc_hd__decap_8
XFILLER_12_112 VPWR VGND VPWR VGND sky130_ef_sc_hd__decap_12
XFILLER_16_97 VGND VGND VPWR VPWR sky130_fd_sc_hd__fill_2
XTAP_TAPCELL_ROW_7_182 VGND VPWR sky130_fd_sc_hd__tapvpwrvgnd_1
Xhold105 u_fifo.mem\[7\]\[4\] VGND VGND VPWR VPWR net173 sky130_fd_sc_hd__dlygate4sd3_1
Xhold127 u_fifo.mem\[11\]\[7\] VGND VGND VPWR VPWR net195 sky130_fd_sc_hd__dlygate4sd3_1
Xhold149 u_uart.clk_count\[13\] VGND VGND VPWR VPWR net217 sky130_fd_sc_hd__dlygate4sd3_1
X_1723_ clknet_leaf_9_clk_10mhz _0226_ VGND VGND VPWR VPWR fifo_dout\[6\] sky130_fd_sc_hd__dfxtp_1
X_1654_ clknet_leaf_14_clk_10mhz _0157_ VGND VGND VPWR VPWR u_fifo.mem\[5\]\[3\] sky130_fd_sc_hd__dfxtp_1
Xhold116 u_fifo.mem\[11\]\[0\] VGND VGND VPWR VPWR net184 sky130_fd_sc_hd__dlygate4sd3_1
XFILLER_7_182 VPWR VGND VPWR VGND sky130_ef_sc_hd__decap_12
Xhold138 u_packet_assembler.timer\[20\] VGND VGND VPWR VPWR net206 sky130_fd_sc_hd__dlygate4sd3_1
X_1585_ clknet_leaf_2_clk_10mhz _0089_ net21 VGND VGND VPWR VPWR fifo_din\[3\] sky130_fd_sc_hd__dfrtp_1
X_1019_ u_packet_assembler.timer\[4\] u_packet_assembler.timer\[5\] _0678_ u_packet_assembler.timer\[6\]
+ VGND VGND VPWR VPWR _0685_ sky130_fd_sc_hd__a31o_1
XFILLER_34_292 VGND VGND VPWR VPWR sky130_fd_sc_hd__fill_1
XFILLER_57_373 VGND VGND VPWR VPWR sky130_fd_sc_hd__decap_4
XTAP_TAPCELL_ROW_4_163 VGND VPWR sky130_fd_sc_hd__tapvpwrvgnd_1
X_1370_ _0711_ _0735_ VGND VGND VPWR VPWR _0394_ sky130_fd_sc_hd__nand2_4
XFILLER_63_365 VPWR VGND VPWR VGND sky130_ef_sc_hd__decap_12
XFILLER_63_321 VPWR VGND VPWR VGND sky130_ef_sc_hd__decap_12
XTAP_TAPCELL_ROW_18_254 VGND VPWR sky130_fd_sc_hd__tapvpwrvgnd_1
XTAP_TAPCELL_ROW_61_533 VGND VPWR sky130_fd_sc_hd__tapvpwrvgnd_1
X_1706_ clknet_leaf_12_clk_10mhz _0209_ VGND VGND VPWR VPWR u_fifo.mem\[0\]\[7\] sky130_fd_sc_hd__dfxtp_1
X_1637_ clknet_leaf_15_clk_10mhz _0140_ VGND VGND VPWR VPWR u_fifo.mem\[7\]\[2\] sky130_fd_sc_hd__dfxtp_1
X_1568_ clknet_leaf_13_clk_10mhz _0076_ VGND VGND VPWR VPWR u_fifo.mem\[15\]\[7\]
+ sky130_fd_sc_hd__dfxtp_1
X_1499_ clknet_leaf_2_clk_10mhz _0025_ net56 VGND VGND VPWR VPWR u_srf_ctrl.timer\[3\]
+ sky130_fd_sc_hd__dfrtp_1
XFILLER_54_365 VPWR VGND VPWR VGND sky130_ef_sc_hd__decap_12
Xfanout33 u_fifo.rd_ptr\[1\] VGND VGND VPWR VPWR net33 sky130_fd_sc_hd__clkbuf_4
Xfanout55 net57 VGND VGND VPWR VPWR net55 sky130_fd_sc_hd__clkbuf_2
Xfanout44 net45 VGND VGND VPWR VPWR net44 sky130_fd_sc_hd__buf_2
XTAP_TAPCELL_ROW_1_144 VGND VPWR sky130_fd_sc_hd__tapvpwrvgnd_1
Xfanout22 u_max30102_ctrl.rst_n VGND VGND VPWR VPWR net22 sky130_fd_sc_hd__clkbuf_4
XFILLER_1_111 VGND VGND VPWR VPWR sky130_fd_sc_hd__fill_1
XFILLER_1_166 VGND VGND VPWR VPWR sky130_fd_sc_hd__fill_2
XFILLER_8_3 VPWR VGND VPWR VGND sky130_ef_sc_hd__decap_12
XFILLER_60_357 VGND VGND VPWR VPWR sky130_fd_sc_hd__decap_6
XFILLER_9_233 VGND VGND VPWR VPWR sky130_fd_sc_hd__decap_4
XFILLER_13_273 VGND VGND VPWR VPWR sky130_fd_sc_hd__fill_1
XTAP_TAPCELL_ROW_15_235 VGND VPWR sky130_fd_sc_hd__tapvpwrvgnd_1
X_0870_ u_srf_ctrl.timer\[3\] _0559_ VGND VGND VPWR VPWR _0562_ sky130_fd_sc_hd__xnor2_1
Xclkload25 clknet_leaf_13_clk_10mhz VGND VGND VPWR VPWR clkload25/X sky130_fd_sc_hd__clkbuf_8
X_1422_ u_uart.bit_index\[1\] u_uart.bit_index\[0\] VGND VGND VPWR VPWR _0417_ sky130_fd_sc_hd__and2_1
Xclkload14 clknet_leaf_9_clk_10mhz VGND VGND VPWR VPWR clkload14/Y sky130_fd_sc_hd__inv_6
X_1284_ u_fifo.mem\[7\]\[0\] _0305_ _0308_ u_fifo.mem\[5\]\[0\] VGND VGND VPWR VPWR
+ _0316_ sky130_fd_sc_hd__a22o_1
X_1353_ u_fifo.mem\[6\]\[6\] _0297_ _0300_ u_fifo.mem\[8\]\[6\] VGND VGND VPWR VPWR
+ _0379_ sky130_fd_sc_hd__a22o_1
XFILLER_51_346 VPWR VGND VPWR VGND sky130_ef_sc_hd__decap_12
XFILLER_51_335 VGND VGND VPWR VPWR sky130_fd_sc_hd__fill_1
XFILLER_51_313 VGND VGND VPWR VPWR sky130_fd_sc_hd__fill_1
XFILLER_36_365 VPWR VGND VPWR VGND sky130_ef_sc_hd__decap_12
XFILLER_36_332 VGND VGND VPWR VPWR sky130_fd_sc_hd__decap_8
Xclkload8 clknet_leaf_28_clk_10mhz VGND VGND VPWR VPWR clkload8/Y sky130_fd_sc_hd__clkinv_8
X_0999_ u_packet_assembler.timer\[19\] u_packet_assembler.timer\[18\] u_packet_assembler.timer\[17\]
+ _0670_ VGND VGND VPWR VPWR _0671_ sky130_fd_sc_hd__or4_1
XTAP_TAPCELL_ROW_29_327 VGND VPWR sky130_fd_sc_hd__tapvpwrvgnd_1
XFILLER_42_313 VGND VGND VPWR VPWR sky130_fd_sc_hd__fill_1
XTAP_TAPCELL_ROW_12_216 VGND VPWR sky130_fd_sc_hd__tapvpwrvgnd_1
XFILLER_60_110 VGND VGND VPWR VPWR sky130_fd_sc_hd__decap_6
XFILLER_1_57 VPWR VGND VPWR VGND sky130_ef_sc_hd__decap_12
XFILLER_18_365 VPWR VGND VPWR VGND sky130_ef_sc_hd__decap_12
XPHY_EDGE_ROW_23_Left_87 VGND VGND VPWR VPWR sky130_fd_sc_hd__decap_3
X_0922_ u_srf_ctrl.timer\[19\] _0596_ VGND VGND VPWR VPWR _0598_ sky130_fd_sc_hd__or2_1
X_0853_ _0477_ u_packet_assembler.state\[3\] _0548_ VGND VGND VPWR VPWR _0549_ sky130_fd_sc_hd__o21bai_1
X_1405_ _0410_ _0411_ VGND VGND VPWR VPWR _0245_ sky130_fd_sc_hd__nor2_1
X_0784_ u_srf_ctrl.echo_counter\[5\] u_srf_ctrl.echo_counter\[4\] net28 u_srf_ctrl.echo_counter\[2\]
+ VGND VGND VPWR VPWR _0499_ sky130_fd_sc_hd__or4_1
X_1336_ _0363_ net224 _0296_ VGND VGND VPWR VPWR _0224_ sky130_fd_sc_hd__mux2_1
Xinput1 rst_n VGND VGND VPWR VPWR net1 sky130_fd_sc_hd__clkbuf_1
X_1267_ net34 net31 _0475_ VGND VGND VPWR VPWR _0299_ sky130_fd_sc_hd__or3_2
X_1198_ u_fifo.wr_ptr\[2\] u_fifo.wr_ptr\[3\] _0709_ VGND VGND VPWR VPWR _0280_ sky130_fd_sc_hd__nor3b_1
XTAP_TAPCELL_ROW_26_308 VGND VPWR sky130_fd_sc_hd__tapvpwrvgnd_1
XFILLER_3_217 VGND VGND VPWR VPWR sky130_fd_sc_hd__decap_6
XFILLER_19_129 VGND VGND VPWR VPWR sky130_fd_sc_hd__decap_3
XFILLER_15_335 VGND VGND VPWR VPWR sky130_fd_sc_hd__fill_1
XTAP_TAPCELL_ROW_40_399 VGND VPWR sky130_fd_sc_hd__tapvpwrvgnd_1
XFILLER_35_96 VPWR VGND VPWR VGND sky130_ef_sc_hd__decap_12
X_1121_ net39 net208 _0733_ VGND VGND VPWR VPWR _0104_ sky130_fd_sc_hd__mux2_1
X_1052_ u_packet_assembler.timer\[15\] _0708_ _0707_ VGND VGND VPWR VPWR _0060_ sky130_fd_sc_hd__o21a_1
XFILLER_33_121 VPWR VGND VPWR VGND sky130_ef_sc_hd__decap_12
XFILLER_21_305 VPWR VGND VPWR VGND sky130_ef_sc_hd__decap_12
XFILLER_21_349 VPWR VGND VPWR VGND sky130_ef_sc_hd__decap_12
X_0905_ u_srf_ctrl.timer\[14\] u_srf_ctrl.timer\[13\] _0579_ VGND VGND VPWR VPWR _0586_
+ sky130_fd_sc_hd__nand3_1
X_0767_ _0483_ _0484_ u_srf_ctrl.timer\[20\] VGND VGND VPWR VPWR _0485_ sky130_fd_sc_hd__a21oi_1
X_0836_ net246 _0536_ VGND VGND VPWR VPWR _0006_ sky130_fd_sc_hd__xor2_1
XFILLER_0_209 VPWR VGND VPWR VGND sky130_ef_sc_hd__decap_12
Xclkbuf_leaf_13_clk_10mhz clknet_2_3__leaf_clk_10mhz VGND VGND VPWR VPWR clknet_leaf_13_clk_10mhz
+ sky130_fd_sc_hd__clkbuf_8
XFILLER_56_246 VGND VGND VPWR VPWR sky130_fd_sc_hd__decap_6
X_1319_ u_fifo.mem\[8\]\[3\] _0300_ _0309_ u_fifo.mem\[9\]\[3\] _0347_ VGND VGND VPWR
+ VPWR _0348_ sky130_fd_sc_hd__a221o_1
XTAP_TAPCELL_ROW_53_480 VGND VPWR sky130_fd_sc_hd__tapvpwrvgnd_1
X_1670_ clknet_leaf_11_clk_10mhz _0173_ VGND VGND VPWR VPWR u_fifo.mem\[3\]\[3\] sky130_fd_sc_hd__dfxtp_1
XFILLER_38_235 VGND VGND VPWR VPWR sky130_fd_sc_hd__fill_1
XFILLER_38_224 VGND VGND VPWR VPWR sky130_fd_sc_hd__fill_2
X_1035_ u_packet_assembler.timer\[11\] u_packet_assembler.timer\[10\] _0691_ VGND
+ VGND VPWR VPWR _0696_ sky130_fd_sc_hd__and3_1
X_1104_ net39 _0728_ _0021_ VGND VGND VPWR VPWR _0092_ sky130_fd_sc_hd__mux2_1
XFILLER_21_113 VGND VGND VPWR VPWR sky130_fd_sc_hd__decap_6
XFILLER_21_146 VGND VGND VPWR VPWR sky130_fd_sc_hd__decap_8
XPHY_EDGE_ROW_26_Left_90 VGND VGND VPWR VPWR sky130_fd_sc_hd__decap_3
X_0819_ _0527_ VGND VGND VPWR VPWR _0528_ sky130_fd_sc_hd__inv_2
XPHY_EDGE_ROW_10_Left_74 VGND VGND VPWR VPWR sky130_fd_sc_hd__decap_3
XFILLER_29_279 VGND VGND VPWR VPWR sky130_fd_sc_hd__fill_1
XFILLER_12_124 VPWR VGND VPWR VGND sky130_ef_sc_hd__decap_12
XTAP_TAPCELL_ROW_50_461 VGND VPWR sky130_fd_sc_hd__tapvpwrvgnd_1
XTAP_TAPCELL_ROW_7_183 VGND VPWR sky130_fd_sc_hd__tapvpwrvgnd_1
XFILLER_57_61 VPWR VGND VPWR VGND sky130_ef_sc_hd__decap_12
XFILLER_57_50 VGND VGND VPWR VPWR sky130_fd_sc_hd__fill_1
XFILLER_28_290 VGND VGND VPWR VPWR sky130_fd_sc_hd__decap_6
Xhold117 u_fifo.mem\[13\]\[5\] VGND VGND VPWR VPWR net185 sky130_fd_sc_hd__dlygate4sd3_1
Xhold139 u_uart.tx_data_reg\[5\] VGND VGND VPWR VPWR net207 sky130_fd_sc_hd__dlygate4sd3_1
X_1653_ clknet_leaf_8_clk_10mhz _0156_ VGND VGND VPWR VPWR u_fifo.mem\[5\]\[2\] sky130_fd_sc_hd__dfxtp_1
X_1722_ clknet_leaf_8_clk_10mhz _0225_ VGND VGND VPWR VPWR fifo_dout\[5\] sky130_fd_sc_hd__dfxtp_1
Xhold128 u_fifo.mem\[9\]\[0\] VGND VGND VPWR VPWR net196 sky130_fd_sc_hd__dlygate4sd3_1
Xhold106 u_fifo.mem\[9\]\[2\] VGND VGND VPWR VPWR net174 sky130_fd_sc_hd__dlygate4sd3_1
XFILLER_7_194 VPWR VGND VPWR VGND sky130_ef_sc_hd__decap_12
XPHY_EDGE_ROW_9_Right_9 VGND VGND VPWR VPWR sky130_fd_sc_hd__decap_3
X_1584_ clknet_leaf_25_clk_10mhz _0088_ net22 VGND VGND VPWR VPWR fifo_din\[2\] sky130_fd_sc_hd__dfrtp_1
XFILLER_26_249 VGND VGND VPWR VPWR sky130_fd_sc_hd__decap_3
XFILLER_26_205 VGND VGND VPWR VPWR sky130_fd_sc_hd__decap_8
X_1018_ _0683_ VGND VGND VPWR VPWR _0684_ sky130_fd_sc_hd__inv_2
XFILLER_1_337 VPWR VGND VPWR VGND sky130_ef_sc_hd__decap_12
XFILLER_27_86 VGND VGND VPWR VPWR sky130_fd_sc_hd__fill_1
XTAP_TAPCELL_ROW_4_164 VGND VPWR sky130_fd_sc_hd__tapvpwrvgnd_1
XTAP_TAPCELL_ROW_10_199 VGND VPWR sky130_fd_sc_hd__tapvpwrvgnd_1
XFILLER_4_186 VGND VGND VPWR VPWR sky130_fd_sc_hd__fill_1
XFILLER_63_333 VGND VGND VPWR VPWR sky130_fd_sc_hd__decap_3
XTAP_TAPCELL_ROW_61_534 VGND VPWR sky130_fd_sc_hd__tapvpwrvgnd_1
XFILLER_16_282 VGND VGND VPWR VPWR sky130_fd_sc_hd__decap_3
XTAP_TAPCELL_ROW_18_255 VGND VPWR sky130_fd_sc_hd__tapvpwrvgnd_1
X_1705_ clknet_leaf_10_clk_10mhz _0208_ VGND VGND VPWR VPWR u_fifo.mem\[0\]\[6\] sky130_fd_sc_hd__dfxtp_1
XFILLER_58_105 VGND VGND VPWR VPWR sky130_fd_sc_hd__fill_1
X_1567_ clknet_leaf_11_clk_10mhz _0075_ VGND VGND VPWR VPWR u_fifo.mem\[15\]\[6\]
+ sky130_fd_sc_hd__dfxtp_1
X_1636_ clknet_leaf_14_clk_10mhz _0139_ VGND VGND VPWR VPWR u_fifo.mem\[7\]\[1\] sky130_fd_sc_hd__dfxtp_1
XFILLER_58_138 VGND VGND VPWR VPWR sky130_fd_sc_hd__fill_2
X_1498_ clknet_leaf_2_clk_10mhz _0024_ net56 VGND VGND VPWR VPWR u_srf_ctrl.timer\[2\]
+ sky130_fd_sc_hd__dfrtp_1
XTAP_TAPCELL_ROW_1_145 VGND VPWR sky130_fd_sc_hd__tapvpwrvgnd_1
Xfanout34 net35 VGND VGND VPWR VPWR net34 sky130_fd_sc_hd__clkbuf_2
Xfanout56 net57 VGND VGND VPWR VPWR net56 sky130_fd_sc_hd__clkbuf_4
Xfanout23 net25 VGND VGND VPWR VPWR net23 sky130_fd_sc_hd__clkbuf_4
Xfanout12 net13 VGND VGND VPWR VPWR net12 sky130_fd_sc_hd__buf_2
Xfanout45 fifo_din\[3\] VGND VGND VPWR VPWR net45 sky130_fd_sc_hd__clkbuf_4
XFILLER_13_55 VGND VGND VPWR VPWR sky130_fd_sc_hd__fill_1
XFILLER_60_303 VGND VGND VPWR VPWR sky130_fd_sc_hd__decap_4
XFILLER_38_85 VGND VGND VPWR VPWR sky130_fd_sc_hd__decap_8
Xclkload26 clknet_leaf_15_clk_10mhz VGND VGND VPWR VPWR clkload26/Y sky130_fd_sc_hd__clkinvlp_4
XFILLER_9_223 VGND VGND VPWR VPWR sky130_fd_sc_hd__fill_1
XFILLER_9_278 VGND VGND VPWR VPWR sky130_fd_sc_hd__fill_2
XTAP_TAPCELL_ROW_15_236 VGND VPWR sky130_fd_sc_hd__tapvpwrvgnd_1
Xclkload15 clknet_leaf_18_clk_10mhz VGND VGND VPWR VPWR clkload15/X sky130_fd_sc_hd__clkbuf_4
X_1421_ net217 _0493_ VGND VGND VPWR VPWR _0256_ sky130_fd_sc_hd__and2_1
X_1283_ u_fifo.mem\[9\]\[0\] _0309_ _0311_ u_fifo.mem\[4\]\[0\] _0314_ VGND VGND VPWR
+ VPWR _0315_ sky130_fd_sc_hd__a221o_1
X_1352_ u_fifo.mem\[7\]\[6\] _0305_ _0374_ _0376_ _0377_ VGND VGND VPWR VPWR _0378_
+ sky130_fd_sc_hd__a2111o_1
XFILLER_51_358 VPWR VGND VPWR VGND sky130_ef_sc_hd__decap_12
XFILLER_51_303 VGND VGND VPWR VPWR sky130_fd_sc_hd__fill_2
Xclkload9 clknet_leaf_3_clk_10mhz VGND VGND VPWR VPWR clkload9/Y sky130_fd_sc_hd__inv_8
X_0998_ u_packet_assembler.timer\[23\] u_packet_assembler.timer\[22\] u_packet_assembler.timer\[21\]
+ u_packet_assembler.timer\[20\] VGND VGND VPWR VPWR _0670_ sky130_fd_sc_hd__or4_1
X_1619_ clknet_leaf_13_clk_10mhz _0122_ VGND VGND VPWR VPWR u_fifo.mem\[8\]\[0\] sky130_fd_sc_hd__dfxtp_1
XFILLER_54_141 VPWR VGND VPWR VGND sky130_ef_sc_hd__decap_12
XTAP_TAPCELL_ROW_29_328 VGND VPWR sky130_fd_sc_hd__tapvpwrvgnd_1
XTAP_TAPCELL_ROW_12_217 VGND VPWR sky130_fd_sc_hd__tapvpwrvgnd_1
XFILLER_24_98 VGND VGND VPWR VPWR sky130_fd_sc_hd__fill_1
XFILLER_1_69 VPWR VGND VPWR VGND sky130_ef_sc_hd__decap_12
XFILLER_45_185 VGND VGND VPWR VPWR sky130_fd_sc_hd__fill_2
X_0921_ net9 _0594_ _0597_ _0595_ VGND VGND VPWR VPWR _0040_ sky130_fd_sc_hd__a31o_1
XFILLER_53_3 VGND VGND VPWR VPWR sky130_fd_sc_hd__decap_3
X_0783_ u_srf_ctrl.echo_counter\[9\] u_srf_ctrl.echo_counter\[8\] net27 u_srf_ctrl.echo_counter\[6\]
+ VGND VGND VPWR VPWR _0498_ sky130_fd_sc_hd__or4_1
X_0852_ _0545_ _0547_ VGND VGND VPWR VPWR _0548_ sky130_fd_sc_hd__or2_1
X_1404_ net273 _0409_ _0405_ VGND VGND VPWR VPWR _0411_ sky130_fd_sc_hd__o21ai_1
X_1335_ u_fifo.mem\[0\]\[4\] _0322_ _0360_ _0362_ VGND VGND VPWR VPWR _0363_ sky130_fd_sc_hd__o22a_1
X_1197_ net146 net36 _0279_ VGND VGND VPWR VPWR _0169_ sky130_fd_sc_hd__mux2_1
X_1266_ net35 net26 net31 u_fifo.rd_ptr\[3\] VGND VGND VPWR VPWR _0298_ sky130_fd_sc_hd__and4b_4
XTAP_TAPCELL_ROW_26_309 VGND VPWR sky130_fd_sc_hd__tapvpwrvgnd_1
Xinput2 srf_echo VGND VGND VPWR VPWR net2 sky130_fd_sc_hd__clkbuf_1
XFILLER_51_166 VGND VGND VPWR VPWR sky130_fd_sc_hd__fill_2
XFILLER_59_266 VPWR VGND VPWR VGND sky130_ef_sc_hd__decap_12
XFILLER_19_43 VGND VGND VPWR VPWR sky130_fd_sc_hd__fill_1
XFILLER_35_75 VGND VGND VPWR VPWR sky130_fd_sc_hd__fill_1
XFILLER_2_251 VGND VGND VPWR VPWR sky130_fd_sc_hd__fill_1
XPHY_EDGE_ROW_38_Left_102 VGND VGND VPWR VPWR sky130_fd_sc_hd__decap_3
X_1120_ net40 net160 _0733_ VGND VGND VPWR VPWR _0103_ sky130_fd_sc_hd__mux2_1
X_1051_ net13 _0703_ VGND VGND VPWR VPWR _0708_ sky130_fd_sc_hd__and2_1
XFILLER_18_163 VPWR VGND VPWR VGND sky130_ef_sc_hd__decap_12
X_0904_ u_srf_ctrl.timer\[11\] u_srf_ctrl.timer\[10\] _0507_ _0573_ VGND VGND VPWR
+ VPWR _0585_ sky130_fd_sc_hd__and4_1
XFILLER_33_166 VGND VGND VPWR VPWR sky130_fd_sc_hd__fill_2
XFILLER_33_133 VGND VGND VPWR VPWR sky130_fd_sc_hd__decap_6
XFILLER_21_317 VPWR VGND VPWR VGND sky130_ef_sc_hd__decap_12
XPHY_EDGE_ROW_47_Left_111 VGND VGND VPWR VPWR sky130_fd_sc_hd__decap_3
X_0766_ u_srf_ctrl.timer\[19\] u_srf_ctrl.timer\[18\] u_srf_ctrl.timer\[17\] u_srf_ctrl.timer\[16\]
+ VGND VGND VPWR VPWR _0484_ sky130_fd_sc_hd__and4_1
X_0835_ _0536_ _0537_ VGND VGND VPWR VPWR _0020_ sky130_fd_sc_hd__nor2_1
X_1318_ u_fifo.mem\[7\]\[3\] _0305_ _0307_ u_fifo.mem\[10\]\[3\] VGND VGND VPWR VPWR
+ _0347_ sky130_fd_sc_hd__a22o_1
XFILLER_56_269 VGND VGND VPWR VPWR sky130_fd_sc_hd__decap_6
XPHY_EDGE_ROW_56_Left_120 VGND VGND VPWR VPWR sky130_fd_sc_hd__decap_3
X_1249_ net33 net32 _0287_ VGND VGND VPWR VPWR _0289_ sky130_fd_sc_hd__and3_1
Xclkbuf_leaf_17_clk_10mhz clknet_2_2__leaf_clk_10mhz VGND VGND VPWR VPWR clknet_leaf_17_clk_10mhz
+ sky130_fd_sc_hd__clkbuf_8
XFILLER_21_11 VGND VGND VPWR VPWR sky130_fd_sc_hd__decap_3
XFILLER_21_33 VPWR VGND VPWR VGND sky130_ef_sc_hd__decap_12
XFILLER_21_77 VPWR VGND VPWR VGND sky130_ef_sc_hd__decap_12
XFILLER_47_214 VGND VGND VPWR VPWR sky130_fd_sc_hd__decap_8
XTAP_TAPCELL_ROW_53_481 VGND VPWR sky130_fd_sc_hd__tapvpwrvgnd_1
XFILLER_15_155 VGND VGND VPWR VPWR sky130_fd_sc_hd__fill_1
XFILLER_15_166 VGND VGND VPWR VPWR sky130_fd_sc_hd__fill_2
XFILLER_15_177 VGND VGND VPWR VPWR sky130_fd_sc_hd__decap_4
XFILLER_7_68 VGND VGND VPWR VPWR sky130_fd_sc_hd__fill_1
XFILLER_7_35 VGND VGND VPWR VPWR sky130_fd_sc_hd__fill_2
XFILLER_7_332 VGND VGND VPWR VPWR sky130_fd_sc_hd__decap_4
XFILLER_16_3 VGND VGND VPWR VPWR sky130_fd_sc_hd__decap_6
X_1034_ u_packet_assembler.timer\[10\] _0691_ u_packet_assembler.timer\[11\] VGND
+ VGND VPWR VPWR _0695_ sky130_fd_sc_hd__a21o_1
X_1103_ u_packet_assembler.state\[1\] _0714_ _0720_ VGND VGND VPWR VPWR _0728_ sky130_fd_sc_hd__a21o_1
XFILLER_21_136 VGND VGND VPWR VPWR sky130_fd_sc_hd__fill_1
XFILLER_21_169 VGND VGND VPWR VPWR sky130_fd_sc_hd__decap_6
X_0749_ u_srf_ctrl.timer\[12\] VGND VGND VPWR VPWR _0468_ sky130_fd_sc_hd__inv_2
X_0818_ u_max30102_ctrl.clk_div\[1\] u_max30102_ctrl.clk_div\[0\] u_max30102_ctrl.clk_div\[2\]
+ u_max30102_ctrl.clk_div\[3\] VGND VGND VPWR VPWR _0527_ sky130_fd_sc_hd__and4_1
XTAP_TAPCELL_ROW_59_518 VGND VPWR sky130_fd_sc_hd__tapvpwrvgnd_1
XFILLER_44_228 VGND VGND VPWR VPWR sky130_fd_sc_hd__fill_2
XTAP_TAPCELL_ROW_42_407 VGND VPWR sky130_fd_sc_hd__tapvpwrvgnd_1
XFILLER_12_136 VGND VGND VPWR VPWR sky130_fd_sc_hd__decap_4
XFILLER_16_55 VPWR VGND VPWR VGND sky130_ef_sc_hd__decap_12
XTAP_TAPCELL_ROW_50_462 VGND VPWR sky130_fd_sc_hd__tapvpwrvgnd_1
XFILLER_20_191 VGND VGND VPWR VPWR sky130_fd_sc_hd__fill_1
XTAP_TAPCELL_ROW_7_184 VGND VPWR sky130_fd_sc_hd__tapvpwrvgnd_1
XFILLER_57_73 VGND VGND VPWR VPWR sky130_fd_sc_hd__decap_3
XFILLER_43_250 VPWR VGND VPWR VGND sky130_ef_sc_hd__decap_12
X_1721_ clknet_leaf_7_clk_10mhz _0224_ VGND VGND VPWR VPWR fifo_dout\[4\] sky130_fd_sc_hd__dfxtp_1
Xhold107 u_fifo.mem\[15\]\[0\] VGND VGND VPWR VPWR net175 sky130_fd_sc_hd__dlygate4sd3_1
Xhold129 u_fifo.mem\[2\]\[4\] VGND VGND VPWR VPWR net197 sky130_fd_sc_hd__dlygate4sd3_1
X_1652_ clknet_leaf_18_clk_10mhz _0155_ VGND VGND VPWR VPWR u_fifo.mem\[5\]\[1\] sky130_fd_sc_hd__dfxtp_1
X_1583_ clknet_leaf_2_clk_10mhz _0087_ net21 VGND VGND VPWR VPWR fifo_din\[1\] sky130_fd_sc_hd__dfrtp_1
Xhold118 u_fifo.mem\[14\]\[4\] VGND VGND VPWR VPWR net186 sky130_fd_sc_hd__dlygate4sd3_1
X_1017_ u_packet_assembler.timer\[6\] u_packet_assembler.timer\[4\] u_packet_assembler.timer\[5\]
+ _0678_ VGND VGND VPWR VPWR _0683_ sky130_fd_sc_hd__and4_1
XFILLER_57_320 VPWR VGND VPWR VGND sky130_ef_sc_hd__decap_12
XFILLER_1_349 VPWR VGND VPWR VGND sky130_ef_sc_hd__decap_12
XFILLER_1_305 VPWR VGND VPWR VGND sky130_ef_sc_hd__decap_12
XTAP_TAPCELL_ROW_4_165 VGND VPWR sky130_fd_sc_hd__tapvpwrvgnd_1
XFILLER_43_64 VGND VGND VPWR VPWR sky130_fd_sc_hd__decap_6
XFILLER_40_253 VGND VGND VPWR VPWR sky130_fd_sc_hd__decap_4
XTAP_TAPCELL_ROW_61_535 VGND VPWR sky130_fd_sc_hd__tapvpwrvgnd_1
XTAP_TAPCELL_ROW_18_256 VGND VPWR sky130_fd_sc_hd__tapvpwrvgnd_1
X_1704_ clknet_leaf_12_clk_10mhz _0207_ VGND VGND VPWR VPWR u_fifo.mem\[0\]\[5\] sky130_fd_sc_hd__dfxtp_1
X_1635_ clknet_leaf_13_clk_10mhz _0138_ VGND VGND VPWR VPWR u_fifo.mem\[7\]\[0\] sky130_fd_sc_hd__dfxtp_1
X_1566_ clknet_leaf_17_clk_10mhz _0074_ VGND VGND VPWR VPWR u_fifo.mem\[15\]\[5\]
+ sky130_fd_sc_hd__dfxtp_1
X_1497_ clknet_leaf_2_clk_10mhz _0023_ net56 VGND VGND VPWR VPWR u_srf_ctrl.timer\[1\]
+ sky130_fd_sc_hd__dfrtp_1
XTAP_TAPCELL_ROW_1_146 VGND VPWR sky130_fd_sc_hd__tapvpwrvgnd_1
Xfanout35 u_fifo.rd_ptr\[0\] VGND VGND VPWR VPWR net35 sky130_fd_sc_hd__clkbuf_2
Xfanout57 net65 VGND VGND VPWR VPWR net57 sky130_fd_sc_hd__clkbuf_2
Xfanout24 net25 VGND VGND VPWR VPWR net24 sky130_fd_sc_hd__clkbuf_4
XFILLER_13_34 VPWR VGND VPWR VGND sky130_ef_sc_hd__decap_12
Xfanout13 _0672_ VGND VGND VPWR VPWR net13 sky130_fd_sc_hd__buf_2
XFILLER_22_253 VPWR VGND VPWR VGND sky130_ef_sc_hd__decap_12
Xfanout46 net47 VGND VGND VPWR VPWR net46 sky130_fd_sc_hd__clkbuf_2
XFILLER_1_113 VPWR VGND VPWR VGND sky130_ef_sc_hd__decap_12
XFILLER_54_85 VGND VGND VPWR VPWR sky130_fd_sc_hd__decap_6
XFILLER_45_334 VGND VGND VPWR VPWR sky130_fd_sc_hd__fill_2
XTAP_TAPCELL_ROW_15_237 VGND VPWR sky130_fd_sc_hd__tapvpwrvgnd_1
Xclkload27 clknet_leaf_16_clk_10mhz VGND VGND VPWR VPWR clkload27/Y sky130_fd_sc_hd__clkinv_4
Xclkload16 clknet_leaf_19_clk_10mhz VGND VGND VPWR VPWR clkload16/Y sky130_fd_sc_hd__inv_6
X_1420_ net230 _0493_ VGND VGND VPWR VPWR _0255_ sky130_fd_sc_hd__and2_1
X_1351_ u_fifo.mem\[5\]\[6\] _0308_ _0312_ u_fifo.mem\[13\]\[6\] VGND VGND VPWR VPWR
+ _0377_ sky130_fd_sc_hd__a22o_1
X_1282_ u_fifo.mem\[10\]\[0\] _0307_ _0313_ u_fifo.mem\[3\]\[0\] VGND VGND VPWR VPWR
+ _0314_ sky130_fd_sc_hd__a22o_1
XFILLER_48_194 VGND VGND VPWR VPWR sky130_fd_sc_hd__fill_2
XFILLER_63_197 VGND VGND VPWR VPWR sky130_fd_sc_hd__decap_8
X_1618_ clknet_leaf_14_clk_10mhz _0121_ VGND VGND VPWR VPWR u_fifo.mem\[9\]\[7\] sky130_fd_sc_hd__dfxtp_1
X_0997_ _0667_ _0668_ u_packet_assembler.timer\[15\] u_packet_assembler.timer\[16\]
+ VGND VGND VPWR VPWR _0669_ sky130_fd_sc_hd__o211a_1
X_1549_ clknet_leaf_21_clk_10mhz _0015_ net24 VGND VGND VPWR VPWR u_max30102_ctrl.clk_div\[4\]
+ sky130_fd_sc_hd__dfrtp_1
XFILLER_54_153 VGND VGND VPWR VPWR sky130_fd_sc_hd__decap_8
XTAP_TAPCELL_ROW_12_218 VGND VPWR sky130_fd_sc_hd__tapvpwrvgnd_1
XFILLER_1_15 VPWR VGND VPWR VGND sky130_ef_sc_hd__decap_12
XFILLER_41_370 VGND VGND VPWR VPWR sky130_fd_sc_hd__decap_6
X_0920_ _0596_ VGND VGND VPWR VPWR _0597_ sky130_fd_sc_hd__inv_2
XFILLER_5_271 VGND VGND VPWR VPWR sky130_fd_sc_hd__decap_6
X_0851_ u_packet_assembler.state\[3\] _0478_ _0546_ VGND VGND VPWR VPWR _0547_ sky130_fd_sc_hd__and3_1
X_0782_ u_srf_ctrl.echo_counter\[1\] u_srf_ctrl.echo_counter\[0\] VGND VGND VPWR VPWR
+ _0497_ sky130_fd_sc_hd__or2_1
X_1403_ u_uart.clk_count\[2\] _0409_ VGND VGND VPWR VPWR _0410_ sky130_fd_sc_hd__and2_1
X_1334_ u_fifo.mem\[3\]\[4\] _0313_ _0356_ _0361_ VGND VGND VPWR VPWR _0362_ sky130_fd_sc_hd__a211o_1
XFILLER_46_3 VPWR VGND VPWR VGND sky130_ef_sc_hd__decap_12
X_1265_ net34 net33 net31 _0475_ VGND VGND VPWR VPWR _0297_ sky130_fd_sc_hd__and4b_4
XFILLER_5_293 VPWR VGND VPWR VGND sky130_ef_sc_hd__decap_12
XPHY_EDGE_ROW_18_Right_18 VGND VGND VPWR VPWR sky130_fd_sc_hd__decap_3
XFILLER_36_197 VGND VGND VPWR VPWR sky130_fd_sc_hd__decap_4
X_1196_ net106 net38 _0279_ VGND VGND VPWR VPWR _0168_ sky130_fd_sc_hd__mux2_1
XPHY_EDGE_ROW_27_Right_27 VGND VGND VPWR VPWR sky130_fd_sc_hd__decap_3
XFILLER_51_189 VPWR VGND VPWR VGND sky130_ef_sc_hd__decap_12
XPHY_EDGE_ROW_36_Right_36 VGND VGND VPWR VPWR sky130_fd_sc_hd__decap_3
XFILLER_59_278 VGND VGND VPWR VPWR sky130_fd_sc_hd__fill_2
XFILLER_27_153 VPWR VGND VPWR VGND sky130_ef_sc_hd__decap_12
XPHY_EDGE_ROW_45_Right_45 VGND VGND VPWR VPWR sky130_fd_sc_hd__decap_3
XFILLER_42_178 VGND VGND VPWR VPWR sky130_fd_sc_hd__fill_2
XPHY_EDGE_ROW_54_Right_54 VGND VGND VPWR VPWR sky130_fd_sc_hd__decap_3
XPHY_EDGE_ROW_63_Right_63 VGND VGND VPWR VPWR sky130_fd_sc_hd__decap_3
XTAP_TAPCELL_ROW_48_446 VGND VPWR sky130_fd_sc_hd__tapvpwrvgnd_1
X_1050_ _0479_ net13 _0704_ net17 VGND VGND VPWR VPWR _0707_ sky130_fd_sc_hd__a211o_1
XFILLER_18_197 VPWR VGND VPWR VGND sky130_ef_sc_hd__decap_12
X_0903_ u_srf_ctrl.timer\[13\] _0579_ u_srf_ctrl.timer\[14\] VGND VGND VPWR VPWR _0584_
+ sky130_fd_sc_hd__a21o_1
X_0834_ net258 _0534_ VGND VGND VPWR VPWR _0537_ sky130_fd_sc_hd__nor2_1
XFILLER_21_329 VGND VGND VPWR VPWR sky130_fd_sc_hd__decap_6
X_0765_ u_srf_ctrl.timer\[14\] _0482_ u_srf_ctrl.timer\[15\] VGND VGND VPWR VPWR _0483_
+ sky130_fd_sc_hd__a21o_1
X_1248_ net26 _0287_ VGND VGND VPWR VPWR _0211_ sky130_fd_sc_hd__xnor2_1
X_1317_ u_fifo.mem\[6\]\[3\] _0297_ _0306_ u_fifo.mem\[14\]\[3\] _0344_ VGND VGND
+ VPWR VPWR _0346_ sky130_fd_sc_hd__a221o_1
X_1179_ net111 net37 _0742_ VGND VGND VPWR VPWR _0153_ sky130_fd_sc_hd__mux2_1
XFILLER_21_23 VGND VGND VPWR VPWR sky130_fd_sc_hd__decap_4
XFILLER_21_45 VGND VGND VPWR VPWR sky130_fd_sc_hd__decap_4
XFILLER_21_89 VPWR VGND VPWR VGND sky130_ef_sc_hd__decap_12
XFILLER_46_64 VPWR VGND VPWR VGND sky130_ef_sc_hd__decap_12
XFILLER_46_42 VGND VGND VPWR VPWR sky130_fd_sc_hd__fill_2
XTAP_TAPCELL_ROW_45_427 VGND VPWR sky130_fd_sc_hd__tapvpwrvgnd_1
XFILLER_15_123 VGND VGND VPWR VPWR sky130_fd_sc_hd__decap_4
XFILLER_62_41 VPWR VGND VPWR VGND sky130_ef_sc_hd__decap_12
XTAP_TAPCELL_ROW_53_482 VGND VPWR sky130_fd_sc_hd__tapvpwrvgnd_1
X_1782__66 VGND VGND VPWR VPWR _1782__66/HI net66 sky130_fd_sc_hd__conb_1
X_1102_ net40 _0021_ _0717_ _0727_ VGND VGND VPWR VPWR _0091_ sky130_fd_sc_hd__o22a_1
XFILLER_53_207 VGND VGND VPWR VPWR sky130_fd_sc_hd__fill_1
X_1033_ net12 _0693_ _0694_ net16 u_packet_assembler.timer\[10\] VGND VGND VPWR VPWR
+ _0055_ sky130_fd_sc_hd__a32o_1
X_0817_ net254 _0522_ VGND VGND VPWR VPWR _0013_ sky130_fd_sc_hd__xnor2_1
XTAP_TAPCELL_ROW_59_519 VGND VPWR sky130_fd_sc_hd__tapvpwrvgnd_1
X_0748_ u_srf_ctrl.timer\[20\] VGND VGND VPWR VPWR _0467_ sky130_fd_sc_hd__inv_2
XFILLER_29_259 VGND VGND VPWR VPWR sky130_fd_sc_hd__decap_8
XTAP_TAPCELL_ROW_50_463 VGND VPWR sky130_fd_sc_hd__tapvpwrvgnd_1
XTAP_TAPCELL_ROW_42_408 VGND VPWR sky130_fd_sc_hd__tapvpwrvgnd_1
XFILLER_32_11 VGND VGND VPWR VPWR sky130_fd_sc_hd__decap_3
XPHY_EDGE_ROW_0_Right_0 VGND VGND VPWR VPWR sky130_fd_sc_hd__decap_3
XFILLER_8_108 VPWR VGND VPWR VGND sky130_ef_sc_hd__decap_12
XFILLER_16_67 VGND VGND VPWR VPWR sky130_fd_sc_hd__fill_2
XFILLER_4_303 VGND VGND VPWR VPWR sky130_fd_sc_hd__fill_2
XTAP_TAPCELL_ROW_7_185 VGND VPWR sky130_fd_sc_hd__tapvpwrvgnd_1
XFILLER_43_262 VGND VGND VPWR VPWR sky130_fd_sc_hd__decap_4
X_1651_ clknet_leaf_13_clk_10mhz _0154_ VGND VGND VPWR VPWR u_fifo.mem\[5\]\[0\] sky130_fd_sc_hd__dfxtp_1
Xhold108 u_fifo.mem\[15\]\[6\] VGND VGND VPWR VPWR net176 sky130_fd_sc_hd__dlygate4sd3_1
X_1720_ clknet_leaf_8_clk_10mhz _0223_ VGND VGND VPWR VPWR fifo_dout\[3\] sky130_fd_sc_hd__dfxtp_1
XFILLER_11_181 VPWR VGND VPWR VGND sky130_ef_sc_hd__decap_12
Xhold119 fifo_dout\[2\] VGND VGND VPWR VPWR net187 sky130_fd_sc_hd__dlygate4sd3_1
X_1582_ clknet_leaf_25_clk_10mhz _0086_ net21 VGND VGND VPWR VPWR fifo_din\[0\] sky130_fd_sc_hd__dfrtp_1
XFILLER_19_281 VPWR VGND VPWR VGND sky130_ef_sc_hd__decap_12
XFILLER_34_284 VGND VGND VPWR VPWR sky130_fd_sc_hd__decap_8
XFILLER_34_262 VGND VGND VPWR VPWR sky130_fd_sc_hd__decap_4
X_1016_ u_packet_assembler.timer\[5\] net16 net12 _0682_ VGND VGND VPWR VPWR _0050_
+ sky130_fd_sc_hd__a22o_1
XFILLER_57_332 VGND VGND VPWR VPWR sky130_fd_sc_hd__decap_4
XFILLER_57_310 VGND VGND VPWR VPWR sky130_fd_sc_hd__fill_1
XTAP_TAPCELL_ROW_4_166 VGND VPWR sky130_fd_sc_hd__tapvpwrvgnd_1
XFILLER_1_317 VPWR VGND VPWR VGND sky130_ef_sc_hd__decap_12
XFILLER_27_55 VGND VGND VPWR VPWR sky130_fd_sc_hd__fill_1
XFILLER_25_295 VGND VGND VPWR VPWR sky130_fd_sc_hd__fill_1
XFILLER_4_15 VPWR VGND VPWR VGND sky130_ef_sc_hd__decap_12
XFILLER_48_365 VPWR VGND VPWR VGND sky130_ef_sc_hd__decap_12
XFILLER_0_361 VGND VGND VPWR VPWR sky130_fd_sc_hd__decap_3
XTAP_TAPCELL_ROW_61_536 VGND VPWR sky130_fd_sc_hd__tapvpwrvgnd_1
XFILLER_31_276 VGND VGND VPWR VPWR sky130_fd_sc_hd__decap_4
XFILLER_31_210 VPWR VGND VPWR VGND sky130_ef_sc_hd__decap_12
XTAP_TAPCELL_ROW_18_257 VGND VPWR sky130_fd_sc_hd__tapvpwrvgnd_1
X_1703_ clknet_leaf_11_clk_10mhz _0206_ VGND VGND VPWR VPWR u_fifo.mem\[0\]\[4\] sky130_fd_sc_hd__dfxtp_1
X_1634_ clknet_leaf_18_clk_10mhz _0137_ VGND VGND VPWR VPWR u_fifo.mem\[14\]\[7\]
+ sky130_fd_sc_hd__dfxtp_1
X_1565_ clknet_leaf_13_clk_10mhz _0073_ VGND VGND VPWR VPWR u_fifo.mem\[15\]\[4\]
+ sky130_fd_sc_hd__dfxtp_1
X_1496_ clknet_leaf_2_clk_10mhz _0022_ net56 VGND VGND VPWR VPWR u_srf_ctrl.timer\[0\]
+ sky130_fd_sc_hd__dfrtp_1
XFILLER_39_376 VGND VGND VPWR VPWR sky130_fd_sc_hd__fill_1
Xfanout36 net37 VGND VGND VPWR VPWR net36 sky130_fd_sc_hd__clkbuf_2
Xfanout14 _0004_ VGND VGND VPWR VPWR net14 sky130_fd_sc_hd__clkbuf_4
Xfanout58 net65 VGND VGND VPWR VPWR net58 sky130_fd_sc_hd__clkbuf_4
Xfanout25 u_max30102_ctrl.rst_n VGND VGND VPWR VPWR net25 sky130_fd_sc_hd__clkbuf_4
XFILLER_13_46 VGND VGND VPWR VPWR sky130_fd_sc_hd__decap_4
XFILLER_13_57 VPWR VGND VPWR VGND sky130_ef_sc_hd__decap_12
XFILLER_22_265 VPWR VGND VPWR VGND sky130_ef_sc_hd__decap_12
Xfanout47 fifo_din\[2\] VGND VGND VPWR VPWR net47 sky130_fd_sc_hd__buf_2
XFILLER_1_125 VGND VGND VPWR VPWR sky130_fd_sc_hd__decap_6
XFILLER_45_313 VGND VGND VPWR VPWR sky130_fd_sc_hd__decap_4
XFILLER_38_54 VPWR VGND VPWR VGND sky130_ef_sc_hd__decap_12
XFILLER_1_169 VPWR VGND VPWR VGND sky130_ef_sc_hd__decap_12
XFILLER_13_221 VGND VGND VPWR VPWR sky130_fd_sc_hd__decap_3
XFILLER_13_265 VGND VGND VPWR VPWR sky130_fd_sc_hd__decap_8
XFILLER_13_298 VGND VGND VPWR VPWR sky130_fd_sc_hd__fill_1
Xclkload17 clknet_leaf_20_clk_10mhz VGND VGND VPWR VPWR clkload17/Y sky130_fd_sc_hd__clkinv_4
X_1350_ u_fifo.mem\[12\]\[6\] _0298_ _0302_ u_fifo.mem\[1\]\[6\] _0375_ VGND VGND
+ VPWR VPWR _0376_ sky130_fd_sc_hd__a221o_1
X_1281_ net32 _0475_ net34 u_fifo.rd_ptr\[1\] VGND VGND VPWR VPWR _0313_ sky130_fd_sc_hd__and4b_4
XFILLER_63_121 VGND VGND VPWR VPWR sky130_fd_sc_hd__fill_1
X_0996_ u_packet_assembler.timer\[14\] u_packet_assembler.timer\[13\] u_packet_assembler.timer\[12\]
+ u_packet_assembler.timer\[11\] VGND VGND VPWR VPWR _0668_ sky130_fd_sc_hd__or4_1
X_1617_ clknet_leaf_11_clk_10mhz _0120_ VGND VGND VPWR VPWR u_fifo.mem\[9\]\[6\] sky130_fd_sc_hd__dfxtp_1
XFILLER_5_91 VGND VGND VPWR VPWR sky130_fd_sc_hd__fill_1
XFILLER_8_291 VGND VGND VPWR VPWR sky130_fd_sc_hd__decap_8
XFILLER_27_302 VGND VGND VPWR VPWR sky130_fd_sc_hd__fill_1
X_1479_ net276 _0456_ _0458_ VGND VGND VPWR VPWR _0272_ sky130_fd_sc_hd__o21a_1
X_1548_ clknet_leaf_21_clk_10mhz _0014_ net24 VGND VGND VPWR VPWR u_max30102_ctrl.clk_div\[3\]
+ sky130_fd_sc_hd__dfrtp_1
XFILLER_24_45 VGND VGND VPWR VPWR sky130_fd_sc_hd__fill_2
XFILLER_40_77 VGND VGND VPWR VPWR sky130_fd_sc_hd__fill_2
XFILLER_6_3 VPWR VGND VPWR VGND sky130_ef_sc_hd__decap_12
XFILLER_1_27 VPWR VGND VPWR VGND sky130_ef_sc_hd__decap_12
X_0850_ u_packet_assembler.state\[0\] u_packet_assembler.state\[1\] VGND VGND VPWR
+ VPWR _0546_ sky130_fd_sc_hd__nand2_1
XFILLER_60_6 VPWR VGND VPWR VGND sky130_ef_sc_hd__decap_12
X_1402_ _0406_ _0408_ _0409_ VGND VGND VPWR VPWR _0244_ sky130_fd_sc_hd__nor3_1
X_0781_ u_srf_ctrl.echo_counter\[14\] u_srf_ctrl.echo_counter\[10\] VGND VGND VPWR
+ VPWR _0496_ sky130_fd_sc_hd__or2_1
X_1333_ u_fifo.mem\[5\]\[4\] _0308_ _0312_ u_fifo.mem\[13\]\[4\] VGND VGND VPWR VPWR
+ _0361_ sky130_fd_sc_hd__a22o_1
X_1264_ net61 _0286_ VGND VGND VPWR VPWR _0296_ sky130_fd_sc_hd__nand2_4
XFILLER_39_3 VGND VGND VPWR VPWR sky130_fd_sc_hd__decap_4
XFILLER_51_113 VGND VGND VPWR VPWR sky130_fd_sc_hd__decap_6
X_1195_ net113 net40 _0279_ VGND VGND VPWR VPWR _0167_ sky130_fd_sc_hd__mux2_1
XTAP_TAPCELL_ROW_34_355 VGND VPWR sky130_fd_sc_hd__tapvpwrvgnd_1
XFILLER_24_349 VPWR VGND VPWR VGND sky130_ef_sc_hd__decap_12
X_0979_ _0634_ _0635_ _0640_ VGND VGND VPWR VPWR _0653_ sky130_fd_sc_hd__and3_1
XFILLER_27_165 VGND VGND VPWR VPWR sky130_fd_sc_hd__decap_3
XFILLER_35_55 VGND VGND VPWR VPWR sky130_fd_sc_hd__fill_1
XTAP_TAPCELL_ROW_25_300 VGND VPWR sky130_fd_sc_hd__tapvpwrvgnd_1
XFILLER_2_231 VPWR VGND VPWR VGND sky130_ef_sc_hd__decap_12
XFILLER_2_253 VPWR VGND VPWR VGND sky130_ef_sc_hd__decap_12
XTAP_TAPCELL_ROW_48_447 VGND VPWR sky130_fd_sc_hd__tapvpwrvgnd_1
XFILLER_33_113 VGND VGND VPWR VPWR sky130_fd_sc_hd__fill_2
XFILLER_18_121 VPWR VGND VPWR VGND sky130_ef_sc_hd__decap_12
X_0902_ net10 _0582_ _0583_ _0554_ net279 VGND VGND VPWR VPWR _0035_ sky130_fd_sc_hd__a32o_1
XTAP_TAPCELL_ROW_31_336 VGND VPWR sky130_fd_sc_hd__tapvpwrvgnd_1
X_0833_ u_max30102_ctrl.clk_div\[9\] _0534_ VGND VGND VPWR VPWR _0536_ sky130_fd_sc_hd__and2_1
X_0764_ u_srf_ctrl.timer\[9\] _0481_ _0480_ VGND VGND VPWR VPWR _0482_ sky130_fd_sc_hd__a21o_1
X_1316_ u_fifo.mem\[12\]\[3\] _0298_ _0313_ u_fifo.mem\[3\]\[3\] VGND VGND VPWR VPWR
+ _0345_ sky130_fd_sc_hd__a22o_1
X_1247_ _0287_ _0288_ VGND VGND VPWR VPWR _0210_ sky130_fd_sc_hd__nor2_1
X_1178_ net130 net38 _0742_ VGND VGND VPWR VPWR _0152_ sky130_fd_sc_hd__mux2_1
XFILLER_20_363 VGND VGND VPWR VPWR sky130_fd_sc_hd__fill_1
XFILLER_21_57 VPWR VGND VPWR VGND sky130_ef_sc_hd__decap_12
XFILLER_55_271 VGND VGND VPWR VPWR sky130_fd_sc_hd__decap_8
XFILLER_47_249 VGND VGND VPWR VPWR sky130_fd_sc_hd__decap_6
XFILLER_46_76 VGND VGND VPWR VPWR sky130_fd_sc_hd__decap_8
XTAP_TAPCELL_ROW_45_428 VGND VPWR sky130_fd_sc_hd__tapvpwrvgnd_1
Xmax_cap11 _0280_ VGND VGND VPWR VPWR net11 sky130_fd_sc_hd__buf_1
XFILLER_15_113 VGND VGND VPWR VPWR sky130_fd_sc_hd__fill_2
XFILLER_62_53 VGND VGND VPWR VPWR sky130_fd_sc_hd__decap_8
XTAP_TAPCELL_ROW_53_483 VGND VPWR sky130_fd_sc_hd__tapvpwrvgnd_1
XFILLER_30_138 VGND VGND VPWR VPWR sky130_fd_sc_hd__fill_2
XFILLER_7_15 VPWR VGND VPWR VGND sky130_ef_sc_hd__decap_12
XFILLER_11_341 VGND VGND VPWR VPWR sky130_fd_sc_hd__fill_1
XFILLER_11_363 VPWR VGND VPWR VGND sky130_ef_sc_hd__decap_12
XFILLER_38_205 VGND VGND VPWR VPWR sky130_fd_sc_hd__fill_2
X_1032_ u_packet_assembler.timer\[10\] _0691_ VGND VGND VPWR VPWR _0694_ sky130_fd_sc_hd__nand2_1
X_1101_ u_packet_assembler.state\[0\] _0664_ _0718_ _0713_ distance_out\[5\] VGND
+ VGND VPWR VPWR _0727_ sky130_fd_sc_hd__a32o_1
X_0816_ _0522_ _0523_ _0526_ VGND VGND VPWR VPWR _0012_ sky130_fd_sc_hd__and3_1
XTAP_TAPCELL_ROW_42_409 VGND VPWR sky130_fd_sc_hd__tapvpwrvgnd_1
XFILLER_37_260 VGND VGND VPWR VPWR sky130_fd_sc_hd__fill_2
XTAP_TAPCELL_ROW_50_464 VGND VPWR sky130_fd_sc_hd__tapvpwrvgnd_1
XFILLER_12_105 VGND VGND VPWR VPWR sky130_fd_sc_hd__fill_1
Xhold109 u_max30102_ctrl.clk_div\[0\] VGND VGND VPWR VPWR net177 sky130_fd_sc_hd__dlygate4sd3_1
XFILLER_11_193 VGND VGND VPWR VPWR sky130_fd_sc_hd__decap_4
X_1581_ clknet_leaf_20_clk_10mhz _0085_ net24 VGND VGND VPWR VPWR u_max30102_ctrl.scl_internal
+ sky130_fd_sc_hd__dfstp_1
X_1650_ clknet_leaf_18_clk_10mhz _0153_ VGND VGND VPWR VPWR u_fifo.mem\[6\]\[7\] sky130_fd_sc_hd__dfxtp_1
XFILLER_21_3 VGND VGND VPWR VPWR sky130_fd_sc_hd__decap_8
X_1015_ u_packet_assembler.timer\[5\] _0680_ VGND VGND VPWR VPWR _0682_ sky130_fd_sc_hd__xnor2_1
XFILLER_19_293 VPWR VGND VPWR VGND sky130_ef_sc_hd__decap_12
XPHY_EDGE_ROW_14_Left_78 VGND VGND VPWR VPWR sky130_fd_sc_hd__decap_3
XFILLER_1_329 VGND VGND VPWR VPWR sky130_fd_sc_hd__decap_6
XFILLER_43_55 VGND VGND VPWR VPWR sky130_fd_sc_hd__fill_1
XFILLER_43_44 VGND VGND VPWR VPWR sky130_fd_sc_hd__decap_4
XFILLER_4_178 VGND VGND VPWR VPWR sky130_fd_sc_hd__decap_8
XFILLER_4_27 VGND VGND VPWR VPWR sky130_fd_sc_hd__fill_1
XFILLER_16_230 VGND VGND VPWR VPWR sky130_fd_sc_hd__fill_1
XFILLER_31_222 VGND VGND VPWR VPWR sky130_fd_sc_hd__fill_2
XFILLER_16_274 VGND VGND VPWR VPWR sky130_fd_sc_hd__decap_8
X_1702_ clknet_leaf_9_clk_10mhz _0205_ VGND VGND VPWR VPWR u_fifo.mem\[0\]\[3\] sky130_fd_sc_hd__dfxtp_1
X_1564_ clknet_leaf_16_clk_10mhz _0072_ VGND VGND VPWR VPWR u_fifo.mem\[15\]\[3\]
+ sky130_fd_sc_hd__dfxtp_1
X_1633_ clknet_leaf_17_clk_10mhz _0136_ VGND VGND VPWR VPWR u_fifo.mem\[14\]\[6\]
+ sky130_fd_sc_hd__dfxtp_1
X_1495_ clknet_leaf_26_clk_10mhz net71 net53 VGND VGND VPWR VPWR net6 sky130_fd_sc_hd__dfrtp_1
Xfanout26 _0474_ VGND VGND VPWR VPWR net26 sky130_fd_sc_hd__clkbuf_4
Xfanout37 fifo_din\[7\] VGND VGND VPWR VPWR net37 sky130_fd_sc_hd__buf_2
Xfanout15 _0426_ VGND VGND VPWR VPWR net15 sky130_fd_sc_hd__buf_2
Xfanout59 net65 VGND VGND VPWR VPWR net59 sky130_fd_sc_hd__clkbuf_2
Xfanout48 net49 VGND VGND VPWR VPWR net48 sky130_fd_sc_hd__buf_2
XFILLER_13_69 VGND VGND VPWR VPWR sky130_fd_sc_hd__decap_3
XFILLER_22_277 VPWR VGND VPWR VGND sky130_ef_sc_hd__decap_12
XFILLER_57_185 VGND VGND VPWR VPWR sky130_fd_sc_hd__decap_4
XFILLER_38_66 VGND VGND VPWR VPWR sky130_fd_sc_hd__decap_6
XFILLER_9_237 VGND VGND VPWR VPWR sky130_fd_sc_hd__fill_1
XFILLER_13_277 VGND VGND VPWR VPWR sky130_fd_sc_hd__decap_3
Xclkload18 clknet_leaf_21_clk_10mhz VGND VGND VPWR VPWR clkload18/Y sky130_fd_sc_hd__clkinv_4
XFILLER_48_141 VGND VGND VPWR VPWR sky130_fd_sc_hd__decap_3
X_1280_ net34 net26 net32 u_fifo.rd_ptr\[3\] VGND VGND VPWR VPWR _0312_ sky130_fd_sc_hd__and4_4
XFILLER_0_181 VPWR VGND VPWR VGND sky130_ef_sc_hd__decap_12
XFILLER_63_111 VGND VGND VPWR VPWR sky130_fd_sc_hd__fill_1
X_0995_ u_packet_assembler.timer\[8\] _0666_ u_packet_assembler.timer\[9\] u_packet_assembler.timer\[10\]
+ VGND VGND VPWR VPWR _0667_ sky130_fd_sc_hd__o211a_1
X_1616_ clknet_leaf_10_clk_10mhz _0119_ VGND VGND VPWR VPWR u_fifo.mem\[9\]\[5\] sky130_fd_sc_hd__dfxtp_1
X_1547_ clknet_leaf_21_clk_10mhz _0013_ net24 VGND VGND VPWR VPWR u_max30102_ctrl.clk_div\[2\]
+ sky130_fd_sc_hd__dfrtp_1
XFILLER_39_163 VGND VGND VPWR VPWR sky130_fd_sc_hd__decap_4
X_1478_ _0550_ _0457_ VGND VGND VPWR VPWR _0458_ sky130_fd_sc_hd__nor2_1
XFILLER_50_350 VPWR VGND VPWR VGND sky130_ef_sc_hd__decap_12
XFILLER_42_306 VGND VGND VPWR VPWR sky130_fd_sc_hd__fill_2
XTAP_TAPCELL_ROW_37_375 VGND VPWR sky130_fd_sc_hd__tapvpwrvgnd_1
XFILLER_10_203 VGND VGND VPWR VPWR sky130_fd_sc_hd__fill_1
XFILLER_24_68 VGND VGND VPWR VPWR sky130_fd_sc_hd__decap_8
XFILLER_40_56 VGND VGND VPWR VPWR sky130_fd_sc_hd__fill_1
XFILLER_40_34 VGND VGND VPWR VPWR sky130_fd_sc_hd__decap_6
XPHY_EDGE_ROW_17_Left_81 VGND VGND VPWR VPWR sky130_fd_sc_hd__decap_3
XTAP_TAPCELL_ROW_20_264 VGND VPWR sky130_fd_sc_hd__tapvpwrvgnd_1
XFILLER_33_306 VGND VGND VPWR VPWR sky130_fd_sc_hd__fill_1
XTAP_TAPCELL_ROW_28_320 VGND VPWR sky130_fd_sc_hd__tapvpwrvgnd_1
XFILLER_1_39 VPWR VGND VPWR VGND sky130_ef_sc_hd__decap_12
XFILLER_60_147 VGND VGND VPWR VPWR sky130_fd_sc_hd__fill_1
X_0780_ u_srf_ctrl.echo_counter\[12\] u_srf_ctrl.echo_counter\[8\] VGND VGND VPWR
+ VPWR _0495_ sky130_fd_sc_hd__or2_1
X_1401_ u_uart.clk_count\[1\] u_uart.clk_count\[0\] _0494_ VGND VGND VPWR VPWR _0409_
+ sky130_fd_sc_hd__and3_1
X_1194_ net180 net43 _0279_ VGND VGND VPWR VPWR _0166_ sky130_fd_sc_hd__mux2_1
X_1332_ u_fifo.mem\[12\]\[4\] _0298_ _0354_ _0358_ _0359_ VGND VGND VPWR VPWR _0360_
+ sky130_fd_sc_hd__a2111o_1
XFILLER_36_133 VGND VGND VPWR VPWR sky130_fd_sc_hd__decap_6
X_1263_ net238 _0294_ VGND VGND VPWR VPWR _0219_ sky130_fd_sc_hd__xor2_1
XFILLER_51_169 VPWR VGND VPWR VGND sky130_ef_sc_hd__decap_12
XFILLER_51_136 VGND VGND VPWR VPWR sky130_fd_sc_hd__decap_4
XFILLER_51_103 VGND VGND VPWR VPWR sky130_fd_sc_hd__fill_1
XTAP_TAPCELL_ROW_34_356 VGND VPWR sky130_fd_sc_hd__tapvpwrvgnd_1
XFILLER_32_361 VGND VGND VPWR VPWR sky130_fd_sc_hd__decap_3
XFILLER_10_15 VPWR VGND VPWR VGND sky130_ef_sc_hd__decap_12
X_0978_ _0638_ _0650_ _0643_ VGND VGND VPWR VPWR _0652_ sky130_fd_sc_hd__o21ai_1
XTAP_TAPCELL_ROW_25_301 VGND VPWR sky130_fd_sc_hd__tapvpwrvgnd_1
XFILLER_51_66 VGND VGND VPWR VPWR sky130_fd_sc_hd__decap_4
Xclkbuf_leaf_3_clk_10mhz clknet_2_1__leaf_clk_10mhz VGND VGND VPWR VPWR clknet_leaf_3_clk_10mhz
+ sky130_fd_sc_hd__clkbuf_8
XFILLER_23_361 VPWR VGND VPWR VGND sky130_ef_sc_hd__decap_12
XFILLER_2_265 VGND VGND VPWR VPWR sky130_fd_sc_hd__fill_2
XFILLER_2_243 VGND VGND VPWR VPWR sky130_fd_sc_hd__decap_8
XPHY_EDGE_ROW_2_Left_66 VGND VGND VPWR VPWR sky130_fd_sc_hd__decap_3
XTAP_TAPCELL_ROW_48_448 VGND VPWR sky130_fd_sc_hd__tapvpwrvgnd_1
XFILLER_2_287 VPWR VGND VPWR VGND sky130_ef_sc_hd__decap_12
XFILLER_18_133 VGND VGND VPWR VPWR sky130_fd_sc_hd__decap_6
XFILLER_33_169 VGND VGND VPWR VPWR sky130_fd_sc_hd__fill_2
XFILLER_18_155 VGND VGND VPWR VPWR sky130_fd_sc_hd__fill_1
XFILLER_18_188 VGND VGND VPWR VPWR sky130_fd_sc_hd__decap_8
X_0901_ u_srf_ctrl.timer\[13\] _0579_ VGND VGND VPWR VPWR _0583_ sky130_fd_sc_hd__nand2_1
X_0763_ u_srf_ctrl.timer\[8\] u_srf_ctrl.timer\[7\] u_srf_ctrl.timer\[6\] VGND VGND
+ VPWR VPWR _0481_ sky130_fd_sc_hd__or3_1
XTAP_TAPCELL_ROW_31_337 VGND VPWR sky130_fd_sc_hd__tapvpwrvgnd_1
X_0832_ _0534_ net250 VGND VGND VPWR VPWR _0019_ sky130_fd_sc_hd__nor2_1
XFILLER_51_3 VPWR VGND VPWR VGND sky130_ef_sc_hd__decap_12
X_1315_ net26 u_fifo.mem\[2\]\[3\] _0303_ VGND VGND VPWR VPWR _0344_ sky130_fd_sc_hd__o21ba_1
XFILLER_56_206 VPWR VGND VPWR VGND sky130_ef_sc_hd__decap_12
X_1246_ net35 _0286_ VGND VGND VPWR VPWR _0288_ sky130_fd_sc_hd__nor2_1
X_1177_ net129 net41 _0742_ VGND VGND VPWR VPWR _0151_ sky130_fd_sc_hd__mux2_1
XFILLER_21_69 VGND VGND VPWR VPWR sky130_fd_sc_hd__decap_4
XTAP_TAPCELL_ROW_53_484 VGND VPWR sky130_fd_sc_hd__tapvpwrvgnd_1
XTAP_TAPCELL_ROW_45_429 VGND VPWR sky130_fd_sc_hd__tapvpwrvgnd_1
XFILLER_30_128 VGND VGND VPWR VPWR sky130_fd_sc_hd__decap_3
XFILLER_15_169 VGND VGND VPWR VPWR sky130_fd_sc_hd__fill_1
XFILLER_7_27 VGND VGND VPWR VPWR sky130_fd_sc_hd__decap_8
XFILLER_11_375 VGND VGND VPWR VPWR sky130_fd_sc_hd__fill_2
XFILLER_23_180 VGND VGND VPWR VPWR sky130_fd_sc_hd__fill_1
X_1782__68 VGND VGND VPWR VPWR net68 _1782__68/LO sky130_fd_sc_hd__conb_1
X_1031_ u_packet_assembler.timer\[10\] _0691_ VGND VGND VPWR VPWR _0693_ sky130_fd_sc_hd__or2_1
X_1100_ net42 _0726_ _0021_ VGND VGND VPWR VPWR _0090_ sky130_fd_sc_hd__mux2_1
XFILLER_21_128 VGND VGND VPWR VPWR sky130_fd_sc_hd__decap_3
X_0815_ _0520_ _0521_ _0525_ VGND VGND VPWR VPWR _0526_ sky130_fd_sc_hd__or3_1
XFILLER_29_206 VGND VGND VPWR VPWR sky130_fd_sc_hd__decap_6
XFILLER_52_253 VGND VGND VPWR VPWR sky130_fd_sc_hd__decap_3
X_1229_ net147 net47 _0284_ VGND VGND VPWR VPWR _0196_ sky130_fd_sc_hd__mux2_1
XTAP_TAPCELL_ROW_50_465 VGND VPWR sky130_fd_sc_hd__tapvpwrvgnd_1
XFILLER_7_121 VGND VGND VPWR VPWR sky130_fd_sc_hd__decap_8
X_1580_ clknet_leaf_1_clk_10mhz _0003_ net56 VGND VGND VPWR VPWR u_srf_ctrl.state\[3\]
+ sky130_fd_sc_hd__dfrtp_4
XFILLER_14_3 VGND VGND VPWR VPWR sky130_fd_sc_hd__decap_8
X_1014_ net12 _0680_ _0681_ net16 net265 VGND VGND VPWR VPWR _0049_ sky130_fd_sc_hd__a32o_1
XFILLER_43_23 VGND VGND VPWR VPWR sky130_fd_sc_hd__fill_1
XFILLER_25_242 VGND VGND VPWR VPWR sky130_fd_sc_hd__fill_2
Xclkbuf_2_3__f_clk_10mhz clknet_0_clk_10mhz VGND VGND VPWR VPWR clknet_2_3__leaf_clk_10mhz
+ sky130_fd_sc_hd__clkbuf_16
XPHY_EDGE_ROW_31_Left_95 VGND VGND VPWR VPWR sky130_fd_sc_hd__decap_3
XFILLER_63_337 VPWR VGND VPWR VGND sky130_ef_sc_hd__decap_12
XFILLER_16_253 VGND VGND VPWR VPWR sky130_fd_sc_hd__fill_1
X_1701_ clknet_leaf_7_clk_10mhz _0204_ VGND VGND VPWR VPWR u_fifo.mem\[0\]\[2\] sky130_fd_sc_hd__dfxtp_1
X_1563_ clknet_leaf_15_clk_10mhz _0071_ VGND VGND VPWR VPWR u_fifo.mem\[15\]\[2\]
+ sky130_fd_sc_hd__dfxtp_1
X_1632_ clknet_leaf_17_clk_10mhz _0135_ VGND VGND VPWR VPWR u_fifo.mem\[14\]\[5\]
+ sky130_fd_sc_hd__dfxtp_1
X_1494_ u_max30102_ctrl.scl_internal VGND VGND VPWR VPWR _0745_ sky130_fd_sc_hd__buf_1
Xfanout38 net39 VGND VGND VPWR VPWR net38 sky130_fd_sc_hd__clkbuf_2
Xfanout49 fifo_din\[1\] VGND VGND VPWR VPWR net49 sky130_fd_sc_hd__buf_2
Xfanout16 net18 VGND VGND VPWR VPWR net16 sky130_fd_sc_hd__buf_2
XFILLER_13_15 VGND VGND VPWR VPWR sky130_fd_sc_hd__decap_4
Xfanout27 u_srf_ctrl.echo_counter\[7\] VGND VGND VPWR VPWR net27 sky130_fd_sc_hd__buf_2
XFILLER_22_289 VPWR VGND VPWR VGND sky130_ef_sc_hd__decap_12
XFILLER_38_45 VGND VGND VPWR VPWR sky130_fd_sc_hd__fill_1
XFILLER_1_105 VGND VGND VPWR VPWR sky130_fd_sc_hd__decap_6
XFILLER_60_307 VGND VGND VPWR VPWR sky130_fd_sc_hd__fill_1
XFILLER_57_131 VGND VGND VPWR VPWR sky130_fd_sc_hd__decap_4
XFILLER_45_326 VGND VGND VPWR VPWR sky130_fd_sc_hd__decap_8
XFILLER_45_304 VGND VGND VPWR VPWR sky130_fd_sc_hd__fill_1
XTAP_TAPCELL_ROW_23_284 VGND VPWR sky130_fd_sc_hd__tapvpwrvgnd_1
Xclkload19 clknet_leaf_22_clk_10mhz VGND VGND VPWR VPWR clkload19/Y sky130_fd_sc_hd__bufinv_16
XFILLER_48_186 VGND VGND VPWR VPWR sky130_fd_sc_hd__decap_8
XFILLER_48_175 VGND VGND VPWR VPWR sky130_fd_sc_hd__fill_2
XFILLER_0_193 VGND VGND VPWR VPWR sky130_fd_sc_hd__decap_3
XFILLER_63_167 VGND VGND VPWR VPWR sky130_fd_sc_hd__fill_1
XFILLER_63_134 VGND VGND VPWR VPWR sky130_fd_sc_hd__decap_6
XFILLER_48_197 VGND VGND VPWR VPWR sky130_fd_sc_hd__decap_3
X_0994_ u_packet_assembler.timer\[6\] u_packet_assembler.timer\[5\] u_packet_assembler.timer\[7\]
+ VGND VGND VPWR VPWR _0666_ sky130_fd_sc_hd__o21a_1
X_1615_ clknet_leaf_11_clk_10mhz _0118_ VGND VGND VPWR VPWR u_fifo.mem\[9\]\[4\] sky130_fd_sc_hd__dfxtp_1
X_1477_ u_srf_ctrl.echo_counter\[14\] _0645_ _0454_ VGND VGND VPWR VPWR _0457_ sky130_fd_sc_hd__and3_1
X_1546_ clknet_leaf_21_clk_10mhz _0012_ net24 VGND VGND VPWR VPWR u_max30102_ctrl.clk_div\[1\]
+ sky130_fd_sc_hd__dfrtp_1
XFILLER_27_337 VPWR VGND VPWR VGND sky130_ef_sc_hd__decap_12
XFILLER_50_362 VGND VGND VPWR VPWR sky130_fd_sc_hd__fill_2
XTAP_TAPCELL_ROW_37_376 VGND VPWR sky130_fd_sc_hd__tapvpwrvgnd_1
XFILLER_10_237 VGND VGND VPWR VPWR sky130_fd_sc_hd__decap_4
XTAP_TAPCELL_ROW_20_265 VGND VPWR sky130_fd_sc_hd__tapvpwrvgnd_1
XTAP_TAPCELL_ROW_28_321 VGND VPWR sky130_fd_sc_hd__tapvpwrvgnd_1
XTAP_TAPCELL_ROW_11_210 VGND VPWR sky130_fd_sc_hd__tapvpwrvgnd_1
X_1400_ u_uart.clk_count\[0\] _0494_ u_uart.clk_count\[1\] VGND VGND VPWR VPWR _0408_
+ sky130_fd_sc_hd__a21oi_1
X_1331_ u_fifo.mem\[8\]\[4\] _0300_ _0311_ u_fifo.mem\[4\]\[4\] VGND VGND VPWR VPWR
+ _0359_ sky130_fd_sc_hd__a22o_1
X_1193_ net163 net45 _0279_ VGND VGND VPWR VPWR _0165_ sky130_fd_sc_hd__mux2_1
XFILLER_36_156 VGND VGND VPWR VPWR sky130_fd_sc_hd__fill_2
X_1262_ _0294_ _0295_ VGND VGND VPWR VPWR _0218_ sky130_fd_sc_hd__and2b_1
XFILLER_24_307 VGND VGND VPWR VPWR sky130_fd_sc_hd__fill_1
XTAP_TAPCELL_ROW_34_357 VGND VPWR sky130_fd_sc_hd__tapvpwrvgnd_1
XFILLER_10_27 VGND VGND VPWR VPWR sky130_fd_sc_hd__fill_1
X_0977_ _0638_ _0643_ _0650_ VGND VGND VPWR VPWR _0651_ sky130_fd_sc_hd__or3_1
X_1529_ clknet_leaf_22_clk_10mhz _0054_ net23 VGND VGND VPWR VPWR u_packet_assembler.timer\[9\]
+ sky130_fd_sc_hd__dfrtp_1
XTAP_TAPCELL_ROW_25_302 VGND VPWR sky130_fd_sc_hd__tapvpwrvgnd_1
XPHY_EDGE_ROW_14_Right_14 VGND VGND VPWR VPWR sky130_fd_sc_hd__decap_3
XFILLER_23_373 VGND VGND VPWR VPWR sky130_fd_sc_hd__decap_4
Xclkbuf_leaf_7_clk_10mhz clknet_2_1__leaf_clk_10mhz VGND VGND VPWR VPWR clknet_leaf_7_clk_10mhz
+ sky130_fd_sc_hd__clkbuf_8
XFILLER_2_299 VGND VGND VPWR VPWR sky130_fd_sc_hd__decap_8
XPHY_EDGE_ROW_23_Right_23 VGND VGND VPWR VPWR sky130_fd_sc_hd__decap_3
XTAP_TAPCELL_ROW_48_449 VGND VPWR sky130_fd_sc_hd__tapvpwrvgnd_1
X_0900_ u_srf_ctrl.timer\[13\] _0579_ VGND VGND VPWR VPWR _0582_ sky130_fd_sc_hd__or2_1
XPHY_EDGE_ROW_32_Right_32 VGND VGND VPWR VPWR sky130_fd_sc_hd__decap_3
XTAP_TAPCELL_ROW_31_338 VGND VPWR sky130_fd_sc_hd__tapvpwrvgnd_1
XFILLER_14_340 VPWR VGND VPWR VGND sky130_ef_sc_hd__decap_12
X_0762_ u_srf_ctrl.timer\[13\] u_srf_ctrl.timer\[12\] u_srf_ctrl.timer\[11\] u_srf_ctrl.timer\[10\]
+ VGND VGND VPWR VPWR _0480_ sky130_fd_sc_hd__or4_1
X_0831_ u_max30102_ctrl.clk_div\[7\] _0532_ net249 VGND VGND VPWR VPWR _0535_ sky130_fd_sc_hd__a21oi_1
XFILLER_56_218 VPWR VGND VPWR VGND sky130_ef_sc_hd__decap_12
X_1314_ _0343_ net187 _0296_ VGND VGND VPWR VPWR _0222_ sky130_fd_sc_hd__mux2_1
XFILLER_44_3 VPWR VGND VPWR VGND sky130_ef_sc_hd__decap_12
XPHY_EDGE_ROW_41_Right_41 VGND VGND VPWR VPWR sky130_fd_sc_hd__decap_3
XPHY_EDGE_ROW_50_Right_50 VGND VGND VPWR VPWR sky130_fd_sc_hd__decap_3
X_1245_ net35 fifo_rd_en net4 VGND VGND VPWR VPWR _0287_ sky130_fd_sc_hd__and3_1
X_1176_ net181 net42 _0742_ VGND VGND VPWR VPWR _0150_ sky130_fd_sc_hd__mux2_1
XFILLER_2_83 VGND VGND VPWR VPWR sky130_fd_sc_hd__fill_1
XFILLER_24_137 VGND VGND VPWR VPWR sky130_fd_sc_hd__decap_3
XFILLER_20_321 VPWR VGND VPWR VGND sky130_ef_sc_hd__decap_12
XFILLER_20_365 VPWR VGND VPWR VGND sky130_ef_sc_hd__decap_12
XFILLER_55_262 VGND VGND VPWR VPWR sky130_fd_sc_hd__fill_1
XFILLER_46_262 VGND VGND VPWR VPWR sky130_fd_sc_hd__decap_4
X_1030_ _0691_ _0692_ net266 net18 VGND VGND VPWR VPWR _0054_ sky130_fd_sc_hd__a2bb2o_1
X_0814_ u_max30102_ctrl.clk_div\[1\] u_max30102_ctrl.clk_div\[2\] _0519_ _0524_ VGND
+ VGND VPWR VPWR _0525_ sky130_fd_sc_hd__or4_1
X_1228_ net137 net48 _0284_ VGND VGND VPWR VPWR _0195_ sky130_fd_sc_hd__mux2_1
XFILLER_52_265 VPWR VGND VPWR VGND sky130_ef_sc_hd__decap_12
X_1159_ net169 net39 _0739_ VGND VGND VPWR VPWR _0136_ sky130_fd_sc_hd__mux2_1
XFILLER_16_37 VGND VGND VPWR VPWR sky130_fd_sc_hd__decap_3
XFILLER_57_11 VGND VGND VPWR VPWR sky130_fd_sc_hd__fill_2
XTAP_TAPCELL_ROW_58_511 VGND VPWR sky130_fd_sc_hd__tapvpwrvgnd_1
XFILLER_43_276 VGND VGND VPWR VPWR sky130_fd_sc_hd__decap_4
XPHY_EDGE_ROW_44_Left_108 VGND VGND VPWR VPWR sky130_fd_sc_hd__decap_3
XFILLER_7_166 VGND VGND VPWR VPWR sky130_fd_sc_hd__fill_2
XFILLER_3_361 VPWR VGND VPWR VGND sky130_ef_sc_hd__decap_12
XPHY_EDGE_ROW_53_Left_117 VGND VGND VPWR VPWR sky130_fd_sc_hd__decap_3
X_1013_ u_packet_assembler.timer\[4\] _0678_ VGND VGND VPWR VPWR _0681_ sky130_fd_sc_hd__or2_1
XPHY_EDGE_ROW_62_Left_126 VGND VGND VPWR VPWR sky130_fd_sc_hd__decap_3
XFILLER_8_60 VGND VGND VPWR VPWR sky130_fd_sc_hd__decap_4
XPHY_EDGE_ROW_4_Right_4 VGND VGND VPWR VPWR sky130_fd_sc_hd__decap_3
XFILLER_40_257 VGND VGND VPWR VPWR sky130_fd_sc_hd__fill_1
XFILLER_40_235 VGND VGND VPWR VPWR sky130_fd_sc_hd__decap_6
XFILLER_4_29 VGND VGND VPWR VPWR sky130_fd_sc_hd__decap_4
XFILLER_63_349 VPWR VGND VPWR VGND sky130_ef_sc_hd__decap_12
XFILLER_63_305 VGND VGND VPWR VPWR sky130_fd_sc_hd__decap_3
XFILLER_17_80 VGND VGND VPWR VPWR sky130_fd_sc_hd__decap_3
X_1700_ clknet_leaf_9_clk_10mhz _0203_ VGND VGND VPWR VPWR u_fifo.mem\[0\]\[1\] sky130_fd_sc_hd__dfxtp_1
XFILLER_31_246 VGND VGND VPWR VPWR sky130_fd_sc_hd__decap_6
X_1631_ clknet_leaf_17_clk_10mhz _0134_ VGND VGND VPWR VPWR u_fifo.mem\[14\]\[4\]
+ sky130_fd_sc_hd__dfxtp_1
X_1493_ u_uart.state\[1\] _0466_ _0459_ VGND VGND VPWR VPWR _0278_ sky130_fd_sc_hd__a21o_1
X_1562_ clknet_leaf_14_clk_10mhz _0070_ VGND VGND VPWR VPWR u_fifo.mem\[15\]\[1\]
+ sky130_fd_sc_hd__dfxtp_1
Xclkbuf_leaf_22_clk_10mhz clknet_2_2__leaf_clk_10mhz VGND VGND VPWR VPWR clknet_leaf_22_clk_10mhz
+ sky130_fd_sc_hd__clkbuf_8
XFILLER_39_346 VPWR VGND VPWR VGND sky130_ef_sc_hd__decap_12
Xfanout28 u_srf_ctrl.echo_counter\[3\] VGND VGND VPWR VPWR net28 sky130_fd_sc_hd__clkbuf_2
Xfanout17 net18 VGND VGND VPWR VPWR net17 sky130_fd_sc_hd__clkbuf_2
Xfanout39 fifo_din\[6\] VGND VGND VPWR VPWR net39 sky130_fd_sc_hd__clkbuf_2
XFILLER_38_79 VGND VGND VPWR VPWR sky130_fd_sc_hd__decap_4
XFILLER_54_78 VGND VGND VPWR VPWR sky130_fd_sc_hd__decap_6
XFILLER_13_202 VGND VGND VPWR VPWR sky130_fd_sc_hd__decap_4
XFILLER_9_217 VGND VGND VPWR VPWR sky130_fd_sc_hd__decap_6
XTAP_TAPCELL_ROW_23_285 VGND VPWR sky130_fd_sc_hd__tapvpwrvgnd_1
XFILLER_63_113 VGND VGND VPWR VPWR sky130_fd_sc_hd__decap_8
XTAP_TAPCELL_ROW_14_230 VGND VPWR sky130_fd_sc_hd__tapvpwrvgnd_1
X_0993_ _0663_ _0664_ VGND VGND VPWR VPWR _0665_ sky130_fd_sc_hd__or2_1
X_1614_ clknet_leaf_14_clk_10mhz _0117_ VGND VGND VPWR VPWR u_fifo.mem\[9\]\[3\] sky130_fd_sc_hd__dfxtp_1
XFILLER_8_250 VGND VGND VPWR VPWR sky130_fd_sc_hd__fill_2
X_1476_ _0645_ _0452_ VGND VGND VPWR VPWR _0456_ sky130_fd_sc_hd__and2_1
X_1545_ clknet_leaf_21_clk_10mhz _0005_ net24 VGND VGND VPWR VPWR u_max30102_ctrl.clk_div\[0\]
+ sky130_fd_sc_hd__dfrtp_2
XTAP_TAPCELL_ROW_37_377 VGND VPWR sky130_fd_sc_hd__tapvpwrvgnd_1
XFILLER_27_349 VPWR VGND VPWR VGND sky130_ef_sc_hd__decap_12
XFILLER_24_15 VPWR VGND VPWR VGND sky130_ef_sc_hd__decap_12
XFILLER_50_341 VGND VGND VPWR VPWR sky130_fd_sc_hd__fill_1
XFILLER_10_249 VGND VGND VPWR VPWR sky130_fd_sc_hd__decap_3
XTAP_TAPCELL_ROW_20_266 VGND VPWR sky130_fd_sc_hd__tapvpwrvgnd_1
XFILLER_45_113 VGND VGND VPWR VPWR sky130_fd_sc_hd__decap_4
XTAP_TAPCELL_ROW_28_322 VGND VPWR sky130_fd_sc_hd__tapvpwrvgnd_1
XFILLER_45_157 VGND VGND VPWR VPWR sky130_fd_sc_hd__decap_3
XTAP_TAPCELL_ROW_11_211 VGND VPWR sky130_fd_sc_hd__tapvpwrvgnd_1
XFILLER_14_92 VGND VGND VPWR VPWR sky130_fd_sc_hd__decap_8
X_1261_ u_fifo.wr_ptr\[2\] _0710_ u_fifo.wr_ptr\[3\] VGND VGND VPWR VPWR _0295_ sky130_fd_sc_hd__a21o_1
X_1330_ u_fifo.mem\[1\]\[4\] _0302_ _0306_ u_fifo.mem\[14\]\[4\] _0357_ VGND VGND
+ VPWR VPWR _0358_ sky130_fd_sc_hd__a221o_1
X_1192_ net154 net46 _0279_ VGND VGND VPWR VPWR _0164_ sky130_fd_sc_hd__mux2_1
XTAP_TAPCELL_ROW_34_358 VGND VPWR sky130_fd_sc_hd__tapvpwrvgnd_1
XFILLER_32_341 VPWR VGND VPWR VGND sky130_ef_sc_hd__decap_12
X_0976_ _0634_ _0635_ _0640_ VGND VGND VPWR VPWR _0650_ sky130_fd_sc_hd__a21oi_1
XFILLER_27_113 VGND VGND VPWR VPWR sky130_fd_sc_hd__decap_6
X_1528_ clknet_leaf_22_clk_10mhz _0053_ net23 VGND VGND VPWR VPWR u_packet_assembler.timer\[8\]
+ sky130_fd_sc_hd__dfrtp_1
X_1459_ net27 net15 _0442_ _0445_ VGND VGND VPWR VPWR _0265_ sky130_fd_sc_hd__o211a_1
XFILLER_51_79 VPWR VGND VPWR VGND sky130_ef_sc_hd__decap_12
XFILLER_51_57 VGND VGND VPWR VPWR sky130_fd_sc_hd__fill_2
XFILLER_4_3 VPWR VGND VPWR VGND sky130_ef_sc_hd__decap_12
XTAP_TAPCELL_ROW_31_339 VGND VPWR sky130_fd_sc_hd__tapvpwrvgnd_1
X_0830_ u_max30102_ctrl.clk_div\[7\] u_max30102_ctrl.clk_div\[8\] _0532_ VGND VGND
+ VPWR VPWR _0534_ sky130_fd_sc_hd__and3_1
XFILLER_14_352 VPWR VGND VPWR VGND sky130_ef_sc_hd__decap_12
X_0761_ u_packet_assembler.timer\[15\] VGND VGND VPWR VPWR _0479_ sky130_fd_sc_hd__inv_2
X_1313_ u_fifo.mem\[0\]\[2\] _0322_ _0336_ _0342_ VGND VGND VPWR VPWR _0343_ sky130_fd_sc_hd__o22a_1
X_1244_ fifo_rd_en net4 VGND VGND VPWR VPWR _0286_ sky130_fd_sc_hd__and2_1
XFILLER_37_3 VGND VGND VPWR VPWR sky130_fd_sc_hd__decap_8
X_1175_ net99 net44 _0742_ VGND VGND VPWR VPWR _0149_ sky130_fd_sc_hd__mux2_1
XFILLER_24_127 VGND VGND VPWR VPWR sky130_fd_sc_hd__decap_3
X_0959_ _0623_ _0624_ _0631_ VGND VGND VPWR VPWR _0633_ sky130_fd_sc_hd__a21o_1
XFILLER_20_333 VPWR VGND VPWR VGND sky130_ef_sc_hd__decap_12
XFILLER_21_27 VGND VGND VPWR VPWR sky130_fd_sc_hd__fill_1
XFILLER_55_252 VGND VGND VPWR VPWR sky130_fd_sc_hd__fill_1
XFILLER_11_82 VGND VGND VPWR VPWR sky130_fd_sc_hd__fill_2
XFILLER_61_222 VGND VGND VPWR VPWR sky130_fd_sc_hd__fill_2
XTAP_TAPCELL_ROW_44_420 VGND VPWR sky130_fd_sc_hd__tapvpwrvgnd_1
X_0813_ u_max30102_ctrl.clk_div\[0\] u_max30102_ctrl.clk_div\[3\] VGND VGND VPWR VPWR
+ _0524_ sky130_fd_sc_hd__nand2_1
XFILLER_14_182 VPWR VGND VPWR VGND sky130_ef_sc_hd__decap_12
XFILLER_21_119 VGND VGND VPWR VPWR sky130_fd_sc_hd__fill_1
XFILLER_37_252 VGND VGND VPWR VPWR sky130_fd_sc_hd__decap_8
X_1227_ net100 net51 _0284_ VGND VGND VPWR VPWR _0194_ sky130_fd_sc_hd__mux2_1
X_1158_ net97 net40 _0739_ VGND VGND VPWR VPWR _0135_ sky130_fd_sc_hd__mux2_1
XFILLER_52_277 VGND VGND VPWR VPWR sky130_fd_sc_hd__decap_3
XFILLER_32_26 VGND VGND VPWR VPWR sky130_fd_sc_hd__fill_2
XFILLER_16_27 VGND VGND VPWR VPWR sky130_fd_sc_hd__fill_1
X_1089_ _0477_ _0664_ _0718_ _0713_ distance_out\[1\] VGND VGND VPWR VPWR _0719_ sky130_fd_sc_hd__a32o_1
XTAP_TAPCELL_ROW_58_512 VGND VPWR sky130_fd_sc_hd__tapvpwrvgnd_1
XFILLER_57_45 VGND VGND VPWR VPWR sky130_fd_sc_hd__fill_1
XFILLER_57_89 VGND VGND VPWR VPWR sky130_fd_sc_hd__decap_6
XFILLER_43_266 VGND VGND VPWR VPWR sky130_fd_sc_hd__fill_1
XFILLER_43_233 VGND VGND VPWR VPWR sky130_fd_sc_hd__fill_1
XFILLER_43_222 VGND VGND VPWR VPWR sky130_fd_sc_hd__fill_2
XFILLER_28_230 VPWR VGND VPWR VGND sky130_ef_sc_hd__decap_12
XTAP_TAPCELL_ROW_41_401 VGND VPWR sky130_fd_sc_hd__tapvpwrvgnd_1
XFILLER_3_373 VGND VGND VPWR VPWR sky130_fd_sc_hd__decap_4
X_1012_ u_packet_assembler.timer\[4\] _0678_ VGND VGND VPWR VPWR _0680_ sky130_fd_sc_hd__nand2_1
XFILLER_34_266 VGND VGND VPWR VPWR sky130_fd_sc_hd__fill_1
X_1776_ clknet_leaf_5_clk_10mhz _0278_ net62 VGND VGND VPWR VPWR u_uart.state\[1\]
+ sky130_fd_sc_hd__dfrtp_1
XFILLER_8_83 VGND VGND VPWR VPWR sky130_fd_sc_hd__fill_1
XFILLER_25_222 VGND VGND VPWR VPWR sky130_fd_sc_hd__fill_2
XFILLER_40_225 VGND VGND VPWR VPWR sky130_fd_sc_hd__fill_1
XFILLER_0_321 VPWR VGND VPWR VGND sky130_ef_sc_hd__decap_12
XFILLER_48_336 VPWR VGND VPWR VGND sky130_ef_sc_hd__decap_12
XFILLER_48_325 VGND VGND VPWR VPWR sky130_fd_sc_hd__decap_3
XFILLER_0_365 VPWR VGND VPWR VGND sky130_ef_sc_hd__decap_12
XFILLER_31_225 VGND VGND VPWR VPWR sky130_fd_sc_hd__fill_2
X_1630_ clknet_leaf_18_clk_10mhz _0133_ VGND VGND VPWR VPWR u_fifo.mem\[14\]\[3\]
+ sky130_fd_sc_hd__dfxtp_1
X_1561_ clknet_leaf_11_clk_10mhz _0069_ VGND VGND VPWR VPWR u_fifo.mem\[15\]\[0\]
+ sky130_fd_sc_hd__dfxtp_1
X_1492_ net257 _0465_ VGND VGND VPWR VPWR _0277_ sky130_fd_sc_hd__xnor2_1
Xclkbuf_leaf_26_clk_10mhz clknet_2_0__leaf_clk_10mhz VGND VGND VPWR VPWR clknet_leaf_26_clk_10mhz
+ sky130_fd_sc_hd__clkbuf_8
XFILLER_54_317 VPWR VGND VPWR VGND sky130_ef_sc_hd__decap_12
XFILLER_39_358 VPWR VGND VPWR VGND sky130_ef_sc_hd__decap_12
Xfanout29 u_fifo.wr_ptr\[1\] VGND VGND VPWR VPWR net29 sky130_fd_sc_hd__buf_2
Xfanout18 _0665_ VGND VGND VPWR VPWR net18 sky130_fd_sc_hd__clkbuf_2
XTAP_TAPCELL_ROW_17_250 VGND VPWR sky130_fd_sc_hd__tapvpwrvgnd_1
XFILLER_22_203 VGND VGND VPWR VPWR sky130_fd_sc_hd__fill_1
X_1759_ clknet_leaf_28_clk_10mhz _0262_ net53 VGND VGND VPWR VPWR u_srf_ctrl.echo_counter\[4\]
+ sky130_fd_sc_hd__dfrtp_4
XFILLER_60_309 VPWR VGND VPWR VGND sky130_ef_sc_hd__decap_12
XFILLER_54_35 VPWR VGND VPWR VGND sky130_ef_sc_hd__decap_12
XFILLER_53_361 VPWR VGND VPWR VGND sky130_ef_sc_hd__decap_12
XTAP_TAPCELL_ROW_0_140 VGND VPWR sky130_fd_sc_hd__tapvpwrvgnd_1
XTAP_TAPCELL_ROW_23_286 VGND VPWR sky130_fd_sc_hd__tapvpwrvgnd_1
XFILLER_63_169 VGND VGND VPWR VPWR sky130_fd_sc_hd__decap_8
XTAP_TAPCELL_ROW_14_231 VGND VPWR sky130_fd_sc_hd__tapvpwrvgnd_1
X_0992_ u_packet_assembler.state\[3\] u_packet_assembler.state\[2\] VGND VGND VPWR
+ VPWR _0664_ sky130_fd_sc_hd__or2_1
X_1613_ clknet_leaf_14_clk_10mhz _0116_ VGND VGND VPWR VPWR u_fifo.mem\[9\]\[2\] sky130_fd_sc_hd__dfxtp_1
X_1544_ clknet_leaf_0_clk_10mhz net70 net54 VGND VGND VPWR VPWR u_srf_ctrl.echo_sync_1
+ sky130_fd_sc_hd__dfrtp_1
XFILLER_39_100 VGND VGND VPWR VPWR sky130_fd_sc_hd__decap_8
X_1475_ _0453_ _0455_ u_srf_ctrl.echo_counter\[13\] VGND VGND VPWR VPWR _0271_ sky130_fd_sc_hd__mux2_1
XFILLER_42_309 VGND VGND VPWR VPWR sky130_fd_sc_hd__decap_4
XFILLER_39_199 VGND VGND VPWR VPWR sky130_fd_sc_hd__fill_2
XTAP_TAPCELL_ROW_37_378 VGND VPWR sky130_fd_sc_hd__tapvpwrvgnd_1
XFILLER_24_27 VGND VGND VPWR VPWR sky130_fd_sc_hd__fill_1
XTAP_TAPCELL_ROW_20_267 VGND VPWR sky130_fd_sc_hd__tapvpwrvgnd_1
XFILLER_49_68 VGND VGND VPWR VPWR sky130_fd_sc_hd__fill_2
XFILLER_45_147 VGND VGND VPWR VPWR sky130_fd_sc_hd__fill_1
XFILLER_30_81 VGND VGND VPWR VPWR sky130_fd_sc_hd__decap_3
XFILLER_14_82 VGND VGND VPWR VPWR sky130_fd_sc_hd__fill_2
X_1191_ net145 net48 _0279_ VGND VGND VPWR VPWR _0163_ sky130_fd_sc_hd__mux2_1
XFILLER_39_7 VGND VGND VPWR VPWR sky130_fd_sc_hd__fill_1
X_1260_ u_fifo.wr_ptr\[2\] u_fifo.wr_ptr\[3\] _0710_ VGND VGND VPWR VPWR _0294_ sky130_fd_sc_hd__and3_1
XFILLER_36_125 VGND VGND VPWR VPWR sky130_fd_sc_hd__decap_4
XFILLER_17_361 VPWR VGND VPWR VGND sky130_ef_sc_hd__decap_12
XTAP_TAPCELL_ROW_34_359 VGND VPWR sky130_fd_sc_hd__tapvpwrvgnd_1
XFILLER_32_353 VGND VGND VPWR VPWR sky130_fd_sc_hd__decap_8
X_0975_ _0607_ _0646_ _0647_ VGND VGND VPWR VPWR _0649_ sky130_fd_sc_hd__and3_1
X_1527_ clknet_leaf_22_clk_10mhz _0052_ net23 VGND VGND VPWR VPWR u_packet_assembler.timer\[7\]
+ sky130_fd_sc_hd__dfrtp_1
XFILLER_10_29 VPWR VGND VPWR VGND sky130_ef_sc_hd__decap_12
XFILLER_35_15 VPWR VGND VPWR VGND sky130_ef_sc_hd__decap_12
XFILLER_27_147 VGND VGND VPWR VPWR sky130_fd_sc_hd__fill_2
X_1389_ _0662_ _0661_ net256 _0469_ VGND VGND VPWR VPWR _0241_ sky130_fd_sc_hd__a2bb2o_1
X_1458_ _0444_ VGND VGND VPWR VPWR _0445_ sky130_fd_sc_hd__inv_2
XFILLER_58_250 VGND VGND VPWR VPWR sky130_fd_sc_hd__fill_2
X_0760_ u_packet_assembler.state\[2\] VGND VGND VPWR VPWR _0478_ sky130_fd_sc_hd__inv_2
X_1243_ net75 net36 _0285_ VGND VGND VPWR VPWR _0209_ sky130_fd_sc_hd__mux2_1
XTAP_TAPCELL_ROW_47_440 VGND VPWR sky130_fd_sc_hd__tapvpwrvgnd_1
X_1312_ _0338_ _0339_ _0340_ _0341_ VGND VGND VPWR VPWR _0342_ sky130_fd_sc_hd__or4_2
XFILLER_2_85 VPWR VGND VPWR VGND sky130_ef_sc_hd__decap_12
XFILLER_2_41 VPWR VGND VPWR VGND sky130_ef_sc_hd__decap_12
X_1174_ net74 net46 _0742_ VGND VGND VPWR VPWR _0148_ sky130_fd_sc_hd__mux2_1
XFILLER_17_191 VGND VGND VPWR VPWR sky130_fd_sc_hd__decap_8
X_0889_ u_srf_ctrl.timer\[8\] u_srf_ctrl.timer\[7\] _0567_ u_srf_ctrl.timer\[9\] VGND
+ VGND VPWR VPWR _0575_ sky130_fd_sc_hd__a31o_1
X_0958_ _0628_ _0631_ VGND VGND VPWR VPWR _0632_ sky130_fd_sc_hd__nor2_1
XFILLER_20_345 VPWR VGND VPWR VGND sky130_ef_sc_hd__decap_12
XFILLER_46_25 VGND VGND VPWR VPWR sky130_fd_sc_hd__decap_3
XFILLER_15_106 VGND VGND VPWR VPWR sky130_fd_sc_hd__decap_6
XFILLER_16_9 VGND VGND VPWR VPWR sky130_fd_sc_hd__fill_1
XFILLER_61_289 VPWR VGND VPWR VGND sky130_ef_sc_hd__decap_12
XFILLER_46_275 VPWR VGND VPWR VGND sky130_ef_sc_hd__decap_12
XTAP_TAPCELL_ROW_44_421 VGND VPWR sky130_fd_sc_hd__tapvpwrvgnd_1
X_0812_ u_max30102_ctrl.clk_div\[1\] u_max30102_ctrl.clk_div\[0\] VGND VGND VPWR VPWR
+ _0523_ sky130_fd_sc_hd__or2_1
XFILLER_14_194 VGND VGND VPWR VPWR sky130_fd_sc_hd__fill_2
XFILLER_37_242 VGND VGND VPWR VPWR sky130_fd_sc_hd__fill_1
XFILLER_37_220 VGND VGND VPWR VPWR sky130_fd_sc_hd__decap_4
X_1226_ u_fifo.wr_ptr\[1\] net56 net11 u_fifo.wr_ptr\[0\] VGND VGND VPWR VPWR _0284_
+ sky130_fd_sc_hd__and4b_4
X_1157_ net186 net42 _0739_ VGND VGND VPWR VPWR _0134_ sky130_fd_sc_hd__mux2_1
X_1088_ u_packet_assembler.state\[1\] u_packet_assembler.state\[2\] u_packet_assembler.state\[3\]
+ VGND VGND VPWR VPWR _0718_ sky130_fd_sc_hd__o21ai_1
XTAP_TAPCELL_ROW_58_513 VGND VPWR sky130_fd_sc_hd__tapvpwrvgnd_1
XTAP_TAPCELL_ROW_41_402 VGND VPWR sky130_fd_sc_hd__tapvpwrvgnd_1
XFILLER_28_253 VGND VGND VPWR VPWR sky130_fd_sc_hd__decap_4
XFILLER_28_242 VGND VGND VPWR VPWR sky130_fd_sc_hd__decap_3
XFILLER_11_164 VGND VGND VPWR VPWR sky130_fd_sc_hd__decap_4
XFILLER_34_212 VGND VGND VPWR VPWR sky130_fd_sc_hd__decap_6
X_1011_ net12 _0677_ _0679_ net16 net245 VGND VGND VPWR VPWR _0048_ sky130_fd_sc_hd__a32o_1
XFILLER_19_231 VGND VGND VPWR VPWR sky130_fd_sc_hd__decap_4
X_1775_ clknet_leaf_5_clk_10mhz _0277_ net62 VGND VGND VPWR VPWR u_uart.state\[0\]
+ sky130_fd_sc_hd__dfrtp_2
XFILLER_6_190 VGND VGND VPWR VPWR sky130_fd_sc_hd__fill_1
XFILLER_8_73 VGND VGND VPWR VPWR sky130_fd_sc_hd__fill_1
XFILLER_57_337 VPWR VGND VPWR VGND sky130_ef_sc_hd__decap_12
XFILLER_57_304 VGND VGND VPWR VPWR sky130_fd_sc_hd__decap_6
X_1209_ net112 net50 _0282_ VGND VGND VPWR VPWR _0178_ sky130_fd_sc_hd__mux2_1
XFILLER_43_15 VGND VGND VPWR VPWR sky130_fd_sc_hd__decap_8
XFILLER_25_234 VGND VGND VPWR VPWR sky130_fd_sc_hd__decap_8
XFILLER_4_105 VPWR VGND VPWR VGND sky130_ef_sc_hd__decap_12
XFILLER_0_333 VGND VGND VPWR VPWR sky130_fd_sc_hd__decap_3
XFILLER_48_348 VPWR VGND VPWR VGND sky130_ef_sc_hd__decap_12
XFILLER_48_315 VGND VGND VPWR VPWR sky130_fd_sc_hd__fill_1
XFILLER_16_212 VGND VGND VPWR VPWR sky130_fd_sc_hd__decap_3
XPHY_EDGE_ROW_9_Left_73 VGND VGND VPWR VPWR sky130_fd_sc_hd__decap_3
XFILLER_17_93 VPWR VGND VPWR VGND sky130_ef_sc_hd__decap_12
X_1560_ clknet_leaf_20_clk_10mhz _0011_ net24 VGND VGND VPWR VPWR u_max30102_ctrl.clk_div\[15\]
+ sky130_fd_sc_hd__dfrtp_1
X_1491_ _0470_ _0465_ VGND VGND VPWR VPWR _0466_ sky130_fd_sc_hd__or2_1
XFILLER_54_329 VPWR VGND VPWR VGND sky130_ef_sc_hd__decap_12
Xfanout19 _0554_ VGND VGND VPWR VPWR net19 sky130_fd_sc_hd__buf_2
XTAP_TAPCELL_ROW_60_530 VGND VPWR sky130_fd_sc_hd__tapvpwrvgnd_1
XFILLER_13_29 VGND VGND VPWR VPWR sky130_fd_sc_hd__fill_2
X_1689_ clknet_leaf_16_clk_10mhz _0192_ VGND VGND VPWR VPWR u_fifo.mem\[2\]\[6\] sky130_fd_sc_hd__dfxtp_1
X_1758_ clknet_leaf_27_clk_10mhz _0261_ net52 VGND VGND VPWR VPWR u_srf_ctrl.echo_counter\[3\]
+ sky130_fd_sc_hd__dfrtp_1
XFILLER_57_189 VGND VGND VPWR VPWR sky130_fd_sc_hd__fill_1
XFILLER_38_37 VGND VGND VPWR VPWR sky130_fd_sc_hd__decap_8
XFILLER_54_47 VPWR VGND VPWR VGND sky130_ef_sc_hd__decap_12
XFILLER_53_373 VGND VGND VPWR VPWR sky130_fd_sc_hd__decap_4
XTAP_TAPCELL_ROW_0_130 VGND VPWR sky130_fd_sc_hd__tapvpwrvgnd_1
XPHY_EDGE_ROW_35_Left_99 VGND VGND VPWR VPWR sky130_fd_sc_hd__decap_3
XFILLER_21_281 VPWR VGND VPWR VGND sky130_ef_sc_hd__decap_12
XTAP_TAPCELL_ROW_23_287 VGND VPWR sky130_fd_sc_hd__tapvpwrvgnd_1
XFILLER_48_112 VGND VGND VPWR VPWR sky130_fd_sc_hd__decap_3
XFILLER_0_141 VGND VGND VPWR VPWR sky130_fd_sc_hd__fill_2
XFILLER_28_70 VPWR VGND VPWR VGND sky130_ef_sc_hd__decap_12
X_0991_ u_packet_assembler.state\[0\] u_packet_assembler.state\[1\] VGND VGND VPWR
+ VPWR _0663_ sky130_fd_sc_hd__or2_1
X_1612_ clknet_leaf_14_clk_10mhz _0115_ VGND VGND VPWR VPWR u_fifo.mem\[9\]\[1\] sky130_fd_sc_hd__dfxtp_1
XFILLER_5_85 VGND VGND VPWR VPWR sky130_fd_sc_hd__decap_6
X_1474_ net272 _0454_ _0455_ VGND VGND VPWR VPWR _0270_ sky130_fd_sc_hd__o21a_1
X_1543_ clknet_leaf_18_clk_10mhz _0068_ net25 VGND VGND VPWR VPWR u_packet_assembler.timer\[23\]
+ sky130_fd_sc_hd__dfrtp_1
XFILLER_39_167 VGND VGND VPWR VPWR sky130_fd_sc_hd__fill_1
XPHY_EDGE_ROW_59_Left_123 VGND VGND VPWR VPWR sky130_fd_sc_hd__decap_3
XFILLER_50_365 VPWR VGND VPWR VGND sky130_ef_sc_hd__decap_12
XTAP_TAPCELL_ROW_37_379 VGND VPWR sky130_fd_sc_hd__tapvpwrvgnd_1
XFILLER_40_27 VGND VGND VPWR VPWR sky130_fd_sc_hd__fill_1
XTAP_TAPCELL_ROW_20_268 VGND VPWR sky130_fd_sc_hd__tapvpwrvgnd_1
XFILLER_18_329 VPWR VGND VPWR VGND sky130_ef_sc_hd__decap_12
XFILLER_41_376 VGND VGND VPWR VPWR sky130_fd_sc_hd__fill_1
X_1190_ net125 net50 _0279_ VGND VGND VPWR VPWR _0162_ sky130_fd_sc_hd__mux2_1
XFILLER_39_91 VGND VGND VPWR VPWR sky130_fd_sc_hd__fill_1
XFILLER_36_115 VGND VGND VPWR VPWR sky130_fd_sc_hd__fill_2
XFILLER_36_148 VGND VGND VPWR VPWR sky130_fd_sc_hd__decap_8
XFILLER_32_365 VPWR VGND VPWR VGND sky130_ef_sc_hd__decap_12
XFILLER_17_373 VGND VGND VPWR VPWR sky130_fd_sc_hd__decap_4
X_0974_ _0646_ _0647_ _0607_ VGND VGND VPWR VPWR _0648_ sky130_fd_sc_hd__a21oi_1
X_1526_ clknet_leaf_23_clk_10mhz _0051_ net22 VGND VGND VPWR VPWR u_packet_assembler.timer\[6\]
+ sky130_fd_sc_hd__dfrtp_1
X_1457_ net27 net15 _0440_ VGND VGND VPWR VPWR _0444_ sky130_fd_sc_hd__and3_1
XFILLER_35_27 VPWR VGND VPWR VGND sky130_ef_sc_hd__decap_12
X_1388_ u_srf_ctrl.state\[3\] net237 _0399_ VGND VGND VPWR VPWR _0240_ sky130_fd_sc_hd__o21a_1
XFILLER_51_48 VGND VGND VPWR VPWR sky130_fd_sc_hd__decap_8
XFILLER_51_15 VPWR VGND VPWR VGND sky130_ef_sc_hd__decap_12
XFILLER_50_195 VGND VGND VPWR VPWR sky130_fd_sc_hd__fill_1
XFILLER_35_192 VGND VGND VPWR VPWR sky130_fd_sc_hd__decap_4
XFILLER_14_365 VPWR VGND VPWR VGND sky130_ef_sc_hd__decap_12
XFILLER_41_162 VGND VGND VPWR VPWR sky130_fd_sc_hd__fill_2
X_1311_ u_fifo.mem\[1\]\[2\] _0302_ _0309_ u_fifo.mem\[9\]\[2\] VGND VGND VPWR VPWR
+ _0341_ sky130_fd_sc_hd__a22o_1
XFILLER_49_251 VGND VGND VPWR VPWR sky130_fd_sc_hd__decap_3
XTAP_TAPCELL_ROW_47_441 VGND VPWR sky130_fd_sc_hd__tapvpwrvgnd_1
X_1242_ net84 net38 _0285_ VGND VGND VPWR VPWR _0208_ sky130_fd_sc_hd__mux2_1
X_1173_ net123 net48 _0742_ VGND VGND VPWR VPWR _0147_ sky130_fd_sc_hd__mux2_1
XFILLER_2_97 VPWR VGND VPWR VGND sky130_ef_sc_hd__decap_12
XFILLER_2_53 VPWR VGND VPWR VGND sky130_ef_sc_hd__decap_12
XPHY_EDGE_ROW_10_Right_10 VGND VGND VPWR VPWR sky130_fd_sc_hd__decap_3
XPHY_EDGE_ROW_22_Left_86 VGND VGND VPWR VPWR sky130_fd_sc_hd__decap_3
XTAP_TAPCELL_ROW_30_330 VGND VPWR sky130_fd_sc_hd__tapvpwrvgnd_1
XFILLER_20_357 VGND VGND VPWR VPWR sky130_fd_sc_hd__decap_6
X_0888_ _0573_ VGND VGND VPWR VPWR _0574_ sky130_fd_sc_hd__inv_2
X_0957_ _0613_ _0629_ VGND VGND VPWR VPWR _0631_ sky130_fd_sc_hd__xnor2_1
XFILLER_46_15 VGND VGND VPWR VPWR sky130_fd_sc_hd__decap_6
X_1509_ clknet_leaf_4_clk_10mhz _0035_ net59 VGND VGND VPWR VPWR u_srf_ctrl.timer\[13\]
+ sky130_fd_sc_hd__dfrtp_2
XFILLER_55_298 VPWR VGND VPWR VGND sky130_ef_sc_hd__decap_12
XFILLER_11_313 VGND VGND VPWR VPWR sky130_fd_sc_hd__fill_2
XFILLER_46_287 VGND VGND VPWR VPWR sky130_fd_sc_hd__fill_1
XTAP_TAPCELL_ROW_44_422 VGND VPWR sky130_fd_sc_hd__tapvpwrvgnd_1
X_0811_ u_max30102_ctrl.clk_div\[1\] u_max30102_ctrl.clk_div\[0\] VGND VGND VPWR VPWR
+ _0522_ sky130_fd_sc_hd__nand2_1
XFILLER_52_246 VGND VGND VPWR VPWR sky130_fd_sc_hd__decap_6
X_1225_ net103 net37 _0283_ VGND VGND VPWR VPWR _0193_ sky130_fd_sc_hd__mux2_1
XFILLER_37_298 VPWR VGND VPWR VGND sky130_ef_sc_hd__decap_12
XFILLER_37_276 VGND VGND VPWR VPWR sky130_fd_sc_hd__decap_4
X_1156_ net82 net44 _0739_ VGND VGND VPWR VPWR _0133_ sky130_fd_sc_hd__mux2_1
X_1087_ _0548_ _0021_ VGND VGND VPWR VPWR _0717_ sky130_fd_sc_hd__nand2_1
XFILLER_20_165 VGND VGND VPWR VPWR sky130_fd_sc_hd__fill_1
XFILLER_20_187 VGND VGND VPWR VPWR sky130_fd_sc_hd__decap_4
XTAP_TAPCELL_ROW_58_514 VGND VPWR sky130_fd_sc_hd__tapvpwrvgnd_1
XTAP_TAPCELL_ROW_41_403 VGND VPWR sky130_fd_sc_hd__tapvpwrvgnd_1
XFILLER_7_158 VGND VGND VPWR VPWR sky130_fd_sc_hd__decap_8
XFILLER_7_103 VGND VGND VPWR VPWR sky130_fd_sc_hd__decap_4
XFILLER_22_72 VPWR VGND VPWR VGND sky130_ef_sc_hd__decap_12
XFILLER_34_224 VPWR VGND VPWR VGND sky130_ef_sc_hd__decap_12
X_1010_ _0678_ VGND VGND VPWR VPWR _0679_ sky130_fd_sc_hd__inv_2
XFILLER_19_243 VGND VGND VPWR VPWR sky130_fd_sc_hd__decap_6
X_1774_ clknet_leaf_7_clk_10mhz _0276_ net63 VGND VGND VPWR VPWR u_uart.bit_index\[2\]
+ sky130_fd_sc_hd__dfrtp_1
XFILLER_57_349 VPWR VGND VPWR VGND sky130_ef_sc_hd__decap_12
X_1208_ _0709_ _0711_ _0737_ VGND VGND VPWR VPWR _0282_ sky130_fd_sc_hd__and3_4
XTAP_TAPCELL_ROW_63_550 VGND VPWR sky130_fd_sc_hd__tapvpwrvgnd_1
XPHY_EDGE_ROW_40_Left_104 VGND VGND VPWR VPWR sky130_fd_sc_hd__decap_3
X_1139_ net40 net202 _0736_ VGND VGND VPWR VPWR _0119_ sky130_fd_sc_hd__mux2_1
XFILLER_4_117 VGND VGND VPWR VPWR sky130_fd_sc_hd__decap_3
XFILLER_17_72 VGND VGND VPWR VPWR sky130_fd_sc_hd__decap_8
X_1490_ net14 _0406_ _0460_ VGND VGND VPWR VPWR _0465_ sky130_fd_sc_hd__o21ai_1
Xhold1 net6 VGND VGND VPWR VPWR net69 sky130_fd_sc_hd__dlygate4sd3_1
XFILLER_62_363 VGND VGND VPWR VPWR sky130_fd_sc_hd__fill_1
XPHY_EDGE_ROW_8_Right_8 VGND VGND VPWR VPWR sky130_fd_sc_hd__decap_3
XFILLER_13_19 VGND VGND VPWR VPWR sky130_fd_sc_hd__fill_1
XPHY_EDGE_ROW_39_Right_39 VGND VGND VPWR VPWR sky130_fd_sc_hd__decap_3
X_1688_ clknet_leaf_17_clk_10mhz _0191_ VGND VGND VPWR VPWR u_fifo.mem\[2\]\[5\] sky130_fd_sc_hd__dfxtp_1
X_1757_ clknet_leaf_28_clk_10mhz _0260_ net52 VGND VGND VPWR VPWR u_srf_ctrl.echo_counter\[2\]
+ sky130_fd_sc_hd__dfrtp_1
XFILLER_57_135 VGND VGND VPWR VPWR sky130_fd_sc_hd__fill_1
XFILLER_57_113 VGND VGND VPWR VPWR sky130_fd_sc_hd__fill_2
XFILLER_54_15 VPWR VGND VPWR VGND sky130_ef_sc_hd__decap_12
XTAP_TAPCELL_ROW_0_131 VGND VPWR sky130_fd_sc_hd__tapvpwrvgnd_1
XFILLER_54_59 VGND VGND VPWR VPWR sky130_fd_sc_hd__decap_6
XPHY_EDGE_ROW_48_Right_48 VGND VGND VPWR VPWR sky130_fd_sc_hd__decap_3
XTAP_TAPCELL_ROW_23_288 VGND VPWR sky130_fd_sc_hd__tapvpwrvgnd_1
XPHY_EDGE_ROW_57_Right_57 VGND VGND VPWR VPWR sky130_fd_sc_hd__decap_3
XFILLER_21_293 VPWR VGND VPWR VGND sky130_ef_sc_hd__decap_12
XFILLER_0_164 VGND VGND VPWR VPWR sky130_fd_sc_hd__decap_4
XFILLER_0_197 VPWR VGND VPWR VGND sky130_ef_sc_hd__decap_12
XFILLER_63_149 VPWR VGND VPWR VGND sky130_ef_sc_hd__decap_12
XFILLER_28_82 VGND VGND VPWR VPWR sky130_fd_sc_hd__fill_2
X_1611_ clknet_leaf_8_clk_10mhz _0114_ VGND VGND VPWR VPWR u_fifo.mem\[9\]\[0\] sky130_fd_sc_hd__dfxtp_1
XFILLER_8_231 VGND VGND VPWR VPWR sky130_fd_sc_hd__decap_4
X_0990_ u_srf_ctrl.state\[2\] _0516_ _0553_ net235 VGND VGND VPWR VPWR _0044_ sky130_fd_sc_hd__a22o_1
X_1473_ _0550_ _0453_ VGND VGND VPWR VPWR _0455_ sky130_fd_sc_hd__nor2_1
X_1542_ clknet_leaf_24_clk_10mhz _0067_ u_max30102_ctrl.rst_n VGND VGND VPWR VPWR
+ u_packet_assembler.timer\[22\] sky130_fd_sc_hd__dfrtp_1
XFILLER_39_124 VPWR VGND VPWR VGND sky130_ef_sc_hd__decap_12
XFILLER_39_113 VGND VGND VPWR VPWR sky130_fd_sc_hd__decap_3
XFILLER_27_319 VGND VGND VPWR VPWR sky130_fd_sc_hd__fill_1
XFILLER_50_333 VGND VGND VPWR VPWR sky130_fd_sc_hd__decap_8
XFILLER_24_29 VPWR VGND VPWR VGND sky130_ef_sc_hd__decap_12
XTAP_TAPCELL_ROW_20_269 VGND VPWR sky130_fd_sc_hd__tapvpwrvgnd_1
XFILLER_49_15 VGND VGND VPWR VPWR sky130_fd_sc_hd__fill_1
Xclkbuf_leaf_12_clk_10mhz clknet_2_3__leaf_clk_10mhz VGND VGND VPWR VPWR clknet_leaf_12_clk_10mhz
+ sky130_fd_sc_hd__clkbuf_8
XFILLER_41_311 VGND VGND VPWR VPWR sky130_fd_sc_hd__decap_8
XFILLER_26_363 VGND VGND VPWR VPWR sky130_fd_sc_hd__fill_1
XFILLER_30_94 VGND VGND VPWR VPWR sky130_fd_sc_hd__fill_2
XFILLER_30_61 VPWR VGND VPWR VGND sky130_ef_sc_hd__decap_12
XFILLER_5_223 VGND VGND VPWR VPWR sky130_fd_sc_hd__fill_1
XFILLER_39_70 VGND VGND VPWR VPWR sky130_fd_sc_hd__fill_1
XFILLER_29_190 VGND VGND VPWR VPWR sky130_fd_sc_hd__decap_6
XFILLER_51_119 VGND VGND VPWR VPWR sky130_fd_sc_hd__fill_1
X_0973_ _0636_ _0637_ _0642_ VGND VGND VPWR VPWR _0647_ sky130_fd_sc_hd__a21o_1
XFILLER_59_219 VGND VGND VPWR VPWR sky130_fd_sc_hd__fill_1
X_1525_ clknet_leaf_23_clk_10mhz _0050_ net22 VGND VGND VPWR VPWR u_packet_assembler.timer\[5\]
+ sky130_fd_sc_hd__dfrtp_1
X_1387_ _0648_ _0649_ u_srf_ctrl.state\[3\] VGND VGND VPWR VPWR _0399_ sky130_fd_sc_hd__o21ai_1
XFILLER_19_18 VGND VGND VPWR VPWR sky130_fd_sc_hd__decap_4
X_1456_ u_srf_ctrl.echo_counter\[7\] net15 _0440_ VGND VGND VPWR VPWR _0443_ sky130_fd_sc_hd__and3_1
XFILLER_35_39 VGND VGND VPWR VPWR sky130_fd_sc_hd__decap_6
XFILLER_51_27 VGND VGND VPWR VPWR sky130_fd_sc_hd__fill_1
XFILLER_50_141 VPWR VGND VPWR VGND sky130_ef_sc_hd__decap_12
XTAP_TAPCELL_ROW_33_350 VGND VPWR sky130_fd_sc_hd__tapvpwrvgnd_1
XFILLER_58_285 VGND VGND VPWR VPWR sky130_fd_sc_hd__decap_4
XFILLER_33_108 VGND VGND VPWR VPWR sky130_fd_sc_hd__decap_4
XFILLER_41_71 VGND VGND VPWR VPWR sky130_fd_sc_hd__decap_8
X_1241_ net107 net41 _0285_ VGND VGND VPWR VPWR _0207_ sky130_fd_sc_hd__mux2_1
X_1310_ u_fifo.mem\[8\]\[2\] _0300_ _0305_ u_fifo.mem\[7\]\[2\] VGND VGND VPWR VPWR
+ _0340_ sky130_fd_sc_hd__a22o_1
XFILLER_1_281 VPWR VGND VPWR VGND sky130_ef_sc_hd__decap_12
XFILLER_49_263 VGND VGND VPWR VPWR sky130_fd_sc_hd__decap_6
XTAP_TAPCELL_ROW_47_442 VGND VPWR sky130_fd_sc_hd__tapvpwrvgnd_1
XFILLER_2_65 VPWR VGND VPWR VGND sky130_ef_sc_hd__decap_12
X_1172_ net93 net51 _0742_ VGND VGND VPWR VPWR _0146_ sky130_fd_sc_hd__mux2_1
XFILLER_24_119 VGND VGND VPWR VPWR sky130_fd_sc_hd__decap_8
XTAP_TAPCELL_ROW_30_331 VGND VPWR sky130_fd_sc_hd__tapvpwrvgnd_1
X_0956_ _0613_ _0629_ VGND VGND VPWR VPWR _0630_ sky130_fd_sc_hd__or2_1
X_0887_ u_srf_ctrl.timer\[9\] u_srf_ctrl.timer\[8\] u_srf_ctrl.timer\[7\] _0567_ VGND
+ VGND VPWR VPWR _0573_ sky130_fd_sc_hd__and4_2
XFILLER_55_233 VGND VGND VPWR VPWR sky130_fd_sc_hd__fill_2
X_1508_ clknet_leaf_4_clk_10mhz _0034_ net58 VGND VGND VPWR VPWR u_srf_ctrl.timer\[12\]
+ sky130_fd_sc_hd__dfrtp_1
X_1439_ u_srf_ctrl.echo_counter\[1\] u_srf_ctrl.echo_counter\[0\] u_srf_ctrl.echo_counter\[2\]
+ VGND VGND VPWR VPWR _0431_ sky130_fd_sc_hd__a21o_1
XFILLER_62_15 VPWR VGND VPWR VGND sky130_ef_sc_hd__decap_12
XFILLER_55_244 VGND VGND VPWR VPWR sky130_fd_sc_hd__decap_8
XFILLER_23_141 VGND VGND VPWR VPWR sky130_fd_sc_hd__fill_1
XFILLER_23_163 VGND VGND VPWR VPWR sky130_fd_sc_hd__fill_1
XFILLER_23_185 VGND VGND VPWR VPWR sky130_fd_sc_hd__decap_4
XFILLER_2_3 VPWR VGND VPWR VGND sky130_ef_sc_hd__decap_12
XFILLER_61_225 VGND VGND VPWR VPWR sky130_fd_sc_hd__decap_4
XTAP_TAPCELL_ROW_44_423 VGND VPWR sky130_fd_sc_hd__tapvpwrvgnd_1
XFILLER_61_258 VGND VGND VPWR VPWR sky130_fd_sc_hd__decap_6
XFILLER_14_141 VPWR VGND VPWR VGND sky130_ef_sc_hd__decap_12
XFILLER_14_163 VGND VGND VPWR VPWR sky130_fd_sc_hd__decap_8
X_0810_ u_max30102_ctrl.clk_div\[13\] u_max30102_ctrl.clk_div\[12\] u_max30102_ctrl.clk_div\[15\]
+ u_max30102_ctrl.clk_div\[14\] VGND VGND VPWR VPWR _0521_ sky130_fd_sc_hd__or4_1
X_1224_ net192 net39 _0283_ VGND VGND VPWR VPWR _0192_ sky130_fd_sc_hd__mux2_1
XFILLER_35_3 VPWR VGND VPWR VGND sky130_ef_sc_hd__decap_12
X_1086_ net51 _0716_ _0021_ VGND VGND VPWR VPWR _0086_ sky130_fd_sc_hd__mux2_1
X_1155_ net73 net46 _0739_ VGND VGND VPWR VPWR _0132_ sky130_fd_sc_hd__mux2_1
XTAP_TAPCELL_ROW_50_459 VGND VPWR sky130_fd_sc_hd__tapvpwrvgnd_1
XFILLER_32_29 VGND VGND VPWR VPWR sky130_fd_sc_hd__decap_4
X_0939_ u_srf_ctrl.echo_counter\[9\] u_srf_ctrl.echo_counter\[5\] VGND VGND VPWR VPWR
+ _0613_ sky130_fd_sc_hd__nand2_1
XTAP_TAPCELL_ROW_58_515 VGND VPWR sky130_fd_sc_hd__tapvpwrvgnd_1
XFILLER_43_225 VGND VGND VPWR VPWR sky130_fd_sc_hd__decap_8
XTAP_TAPCELL_ROW_41_404 VGND VPWR sky130_fd_sc_hd__tapvpwrvgnd_1
XFILLER_11_111 VGND VGND VPWR VPWR sky130_fd_sc_hd__fill_1
XFILLER_34_236 VPWR VGND VPWR VGND sky130_ef_sc_hd__decap_12
XFILLER_63_91 VPWR VGND VPWR VGND sky130_ef_sc_hd__decap_12
X_1773_ clknet_leaf_7_clk_10mhz _0275_ net62 VGND VGND VPWR VPWR u_uart.bit_index\[1\]
+ sky130_fd_sc_hd__dfrtp_1
X_1207_ net94 net36 _0281_ VGND VGND VPWR VPWR _0177_ sky130_fd_sc_hd__mux2_1
XFILLER_25_214 VGND VGND VPWR VPWR sky130_fd_sc_hd__decap_8
XTAP_TAPCELL_ROW_63_551 VGND VPWR sky130_fd_sc_hd__tapvpwrvgnd_1
X_1069_ net43 net191 _0712_ VGND VGND VPWR VPWR _0073_ sky130_fd_sc_hd__mux2_1
X_1138_ net43 net165 _0736_ VGND VGND VPWR VPWR _0118_ sky130_fd_sc_hd__mux2_1
XFILLER_63_309 VPWR VGND VPWR VGND sky130_ef_sc_hd__decap_12
XFILLER_56_361 VGND VGND VPWR VPWR sky130_fd_sc_hd__decap_3
XFILLER_16_203 VGND VGND VPWR VPWR sky130_fd_sc_hd__fill_1
XFILLER_16_236 VGND VGND VPWR VPWR sky130_fd_sc_hd__decap_4
XFILLER_17_51 VGND VGND VPWR VPWR sky130_fd_sc_hd__decap_4
XFILLER_3_195 VGND VGND VPWR VPWR sky130_fd_sc_hd__decap_3
Xhold2 u_srf_ctrl.echo_sync_0 VGND VGND VPWR VPWR net70 sky130_fd_sc_hd__dlygate4sd3_1
XFILLER_22_239 VGND VGND VPWR VPWR sky130_fd_sc_hd__decap_3
XFILLER_30_261 VPWR VGND VPWR VGND sky130_ef_sc_hd__decap_12
X_1756_ clknet_leaf_28_clk_10mhz _0259_ net54 VGND VGND VPWR VPWR u_srf_ctrl.echo_counter\[1\]
+ sky130_fd_sc_hd__dfrtp_2
X_1687_ clknet_leaf_16_clk_10mhz _0190_ VGND VGND VPWR VPWR u_fifo.mem\[2\]\[4\] sky130_fd_sc_hd__dfxtp_1
XFILLER_54_27 VGND VGND VPWR VPWR sky130_fd_sc_hd__fill_1
XTAP_TAPCELL_ROW_0_132 VGND VPWR sky130_fd_sc_hd__tapvpwrvgnd_1
XFILLER_13_206 VGND VGND VPWR VPWR sky130_fd_sc_hd__fill_1
XTAP_TAPCELL_ROW_23_289 VGND VPWR sky130_fd_sc_hd__tapvpwrvgnd_1
XFILLER_44_82 VGND VGND VPWR VPWR sky130_fd_sc_hd__fill_2
XFILLER_60_81 VGND VGND VPWR VPWR sky130_fd_sc_hd__decap_3
X_1610_ clknet_leaf_12_clk_10mhz _0113_ VGND VGND VPWR VPWR u_fifo.mem\[10\]\[7\]
+ sky130_fd_sc_hd__dfxtp_1
XFILLER_5_54 VGND VGND VPWR VPWR sky130_fd_sc_hd__fill_2
X_1472_ _0618_ _0632_ _0444_ VGND VGND VPWR VPWR _0454_ sky130_fd_sc_hd__and3_1
X_1541_ clknet_leaf_18_clk_10mhz _0066_ net25 VGND VGND VPWR VPWR u_packet_assembler.timer\[21\]
+ sky130_fd_sc_hd__dfrtp_1
XFILLER_62_150 VPWR VGND VPWR VGND sky130_ef_sc_hd__decap_12
XFILLER_54_106 VGND VGND VPWR VPWR sky130_fd_sc_hd__decap_6
XFILLER_39_136 VPWR VGND VPWR VGND sky130_ef_sc_hd__decap_12
XFILLER_35_353 VPWR VGND VPWR VGND sky130_ef_sc_hd__decap_12
X_1739_ clknet_leaf_6_clk_10mhz _0242_ net63 VGND VGND VPWR VPWR u_uart.busy sky130_fd_sc_hd__dfrtp_1
Xhold210 u_packet_assembler.timer\[2\] VGND VGND VPWR VPWR net278 sky130_fd_sc_hd__dlygate4sd3_1
XFILLER_45_117 VGND VGND VPWR VPWR sky130_fd_sc_hd__fill_1
XTAP_TAPCELL_ROW_36_370 VGND VPWR sky130_fd_sc_hd__tapvpwrvgnd_1
Xclkbuf_leaf_16_clk_10mhz clknet_2_3__leaf_clk_10mhz VGND VGND VPWR VPWR clknet_leaf_16_clk_10mhz
+ sky130_fd_sc_hd__clkbuf_8
XFILLER_14_74 VGND VGND VPWR VPWR sky130_fd_sc_hd__decap_8
XFILLER_39_60 VGND VGND VPWR VPWR sky130_fd_sc_hd__fill_2
XFILLER_30_73 VGND VGND VPWR VPWR sky130_fd_sc_hd__decap_8
XFILLER_36_139 VGND VGND VPWR VPWR sky130_fd_sc_hd__fill_1
X_0972_ _0634_ _0635_ _0644_ VGND VGND VPWR VPWR _0646_ sky130_fd_sc_hd__a21o_1
X_1524_ clknet_leaf_23_clk_10mhz _0049_ net20 VGND VGND VPWR VPWR u_packet_assembler.timer\[4\]
+ sky130_fd_sc_hd__dfrtp_1
X_1455_ net27 _0440_ _0551_ VGND VGND VPWR VPWR _0442_ sky130_fd_sc_hd__o21a_1
X_1386_ u_srf_ctrl.state\[3\] net229 _0398_ VGND VGND VPWR VPWR _0239_ sky130_fd_sc_hd__o21ba_1
XFILLER_27_139 VGND VGND VPWR VPWR sky130_fd_sc_hd__decap_8
XFILLER_23_301 VGND VGND VPWR VPWR sky130_fd_sc_hd__decap_6
XFILLER_50_175 VPWR VGND VPWR VGND sky130_ef_sc_hd__decap_12
XFILLER_50_153 VGND VGND VPWR VPWR sky130_fd_sc_hd__decap_4
XTAP_TAPCELL_ROW_33_351 VGND VPWR sky130_fd_sc_hd__tapvpwrvgnd_1
XFILLER_58_253 VGND VGND VPWR VPWR sky130_fd_sc_hd__decap_8
XFILLER_58_242 VGND VGND VPWR VPWR sky130_fd_sc_hd__decap_8
XFILLER_18_139 VGND VGND VPWR VPWR sky130_fd_sc_hd__fill_1
XTAP_TAPCELL_ROW_56_498 VGND VPWR sky130_fd_sc_hd__tapvpwrvgnd_1
XFILLER_41_175 VGND VGND VPWR VPWR sky130_fd_sc_hd__fill_1
XFILLER_26_161 VGND VGND VPWR VPWR sky130_fd_sc_hd__decap_8
X_1240_ net79 net42 _0285_ VGND VGND VPWR VPWR _0206_ sky130_fd_sc_hd__mux2_1
XFILLER_49_242 VGND VGND VPWR VPWR sky130_fd_sc_hd__fill_1
X_1171_ u_fifo.wr_ptr\[0\] net29 net60 _0740_ VGND VGND VPWR VPWR _0742_ sky130_fd_sc_hd__and4b_4
XFILLER_2_77 VGND VGND VPWR VPWR sky130_fd_sc_hd__decap_6
XFILLER_1_293 VPWR VGND VPWR VGND sky130_ef_sc_hd__decap_12
XTAP_TAPCELL_ROW_47_443 VGND VPWR sky130_fd_sc_hd__tapvpwrvgnd_1
X_0886_ u_srf_ctrl.timer\[8\] net19 net10 _0572_ VGND VGND VPWR VPWR _0030_ sky130_fd_sc_hd__a22o_1
XFILLER_32_197 VPWR VGND VPWR VGND sky130_ef_sc_hd__decap_12
XTAP_TAPCELL_ROW_30_332 VGND VPWR sky130_fd_sc_hd__tapvpwrvgnd_1
X_0955_ u_srf_ctrl.echo_counter\[10\] u_srf_ctrl.echo_counter\[6\] VGND VGND VPWR
+ VPWR _0629_ sky130_fd_sc_hd__xnor2_1
X_1507_ clknet_leaf_4_clk_10mhz _0033_ net59 VGND VGND VPWR VPWR u_srf_ctrl.timer\[11\]
+ sky130_fd_sc_hd__dfrtp_1
X_1369_ _0393_ net204 _0296_ VGND VGND VPWR VPWR _0227_ sky130_fd_sc_hd__mux2_1
X_1438_ _0429_ VGND VGND VPWR VPWR _0430_ sky130_fd_sc_hd__inv_2
XFILLER_62_27 VGND VGND VPWR VPWR sky130_fd_sc_hd__fill_1
XTAP_TAPCELL_ROW_53_479 VGND VPWR sky130_fd_sc_hd__tapvpwrvgnd_1
XFILLER_11_337 VGND VGND VPWR VPWR sky130_fd_sc_hd__decap_4
XTAP_TAPCELL_ROW_44_424 VGND VPWR sky130_fd_sc_hd__tapvpwrvgnd_1
XFILLER_36_94 VGND VGND VPWR VPWR sky130_fd_sc_hd__fill_1
XFILLER_14_120 VGND VGND VPWR VPWR sky130_fd_sc_hd__fill_1
XFILLER_14_153 VGND VGND VPWR VPWR sky130_fd_sc_hd__decap_6
X_1154_ net78 net48 _0739_ VGND VGND VPWR VPWR _0131_ sky130_fd_sc_hd__mux2_1
X_1223_ net88 net40 _0283_ VGND VGND VPWR VPWR _0191_ sky130_fd_sc_hd__mux2_1
X_1085_ distance_out\[0\] _0713_ _0715_ VGND VGND VPWR VPWR _0716_ sky130_fd_sc_hd__a21o_1
X_0869_ u_srf_ctrl.timer\[1\] u_srf_ctrl.timer\[0\] u_srf_ctrl.timer\[3\] u_srf_ctrl.timer\[2\]
+ VGND VGND VPWR VPWR _0561_ sky130_fd_sc_hd__and4_1
X_0938_ _0608_ _0610_ VGND VGND VPWR VPWR _0612_ sky130_fd_sc_hd__xor2_1
XTAP_TAPCELL_ROW_58_516 VGND VPWR sky130_fd_sc_hd__tapvpwrvgnd_1
XFILLER_51_281 VGND VGND VPWR VPWR sky130_fd_sc_hd__decap_4
XTAP_TAPCELL_ROW_41_405 VGND VPWR sky130_fd_sc_hd__tapvpwrvgnd_1
XFILLER_3_333 VGND VGND VPWR VPWR sky130_fd_sc_hd__decap_3
XFILLER_22_85 VGND VGND VPWR VPWR sky130_fd_sc_hd__fill_2
XFILLER_19_223 VGND VGND VPWR VPWR sky130_fd_sc_hd__fill_1
XFILLER_63_81 VGND VGND VPWR VPWR sky130_fd_sc_hd__decap_3
XFILLER_34_248 VGND VGND VPWR VPWR sky130_fd_sc_hd__decap_4
X_1772_ clknet_leaf_6_clk_10mhz _0274_ net63 VGND VGND VPWR VPWR u_uart.bit_index\[0\]
+ sky130_fd_sc_hd__dfrtp_2
XFILLER_6_171 VGND VGND VPWR VPWR sky130_fd_sc_hd__fill_1
X_1137_ net44 net189 _0736_ VGND VGND VPWR VPWR _0117_ sky130_fd_sc_hd__mux2_1
X_1206_ net126 net39 _0281_ VGND VGND VPWR VPWR _0176_ sky130_fd_sc_hd__mux2_1
XFILLER_25_204 VGND VGND VPWR VPWR sky130_fd_sc_hd__fill_2
XTAP_TAPCELL_ROW_63_552 VGND VPWR sky130_fd_sc_hd__tapvpwrvgnd_1
X_1068_ net44 net168 _0712_ VGND VGND VPWR VPWR _0072_ sky130_fd_sc_hd__mux2_1
XFILLER_16_226 VGND VGND VPWR VPWR sky130_fd_sc_hd__decap_4
XFILLER_16_248 VGND VGND VPWR VPWR sky130_fd_sc_hd__decap_4
XFILLER_33_84 VGND VGND VPWR VPWR sky130_fd_sc_hd__decap_3
XFILLER_62_321 VPWR VGND VPWR VGND sky130_ef_sc_hd__decap_12
Xhold3 u_pmu.user_detected VGND VGND VPWR VPWR net71 sky130_fd_sc_hd__dlygate4sd3_1
XFILLER_62_365 VPWR VGND VPWR VGND sky130_ef_sc_hd__decap_12
XFILLER_30_273 VPWR VGND VPWR VGND sky130_ef_sc_hd__decap_12
XFILLER_30_251 VGND VGND VPWR VPWR sky130_fd_sc_hd__fill_1
XFILLER_15_281 VPWR VGND VPWR VGND sky130_ef_sc_hd__decap_12
X_1686_ clknet_leaf_18_clk_10mhz _0189_ VGND VGND VPWR VPWR u_fifo.mem\[2\]\[3\] sky130_fd_sc_hd__dfxtp_1
X_1755_ clknet_leaf_0_clk_10mhz _0258_ net54 VGND VGND VPWR VPWR u_srf_ctrl.echo_counter\[0\]
+ sky130_fd_sc_hd__dfrtp_2
XTAP_TAPCELL_ROW_0_133 VGND VPWR sky130_fd_sc_hd__tapvpwrvgnd_1
XFILLER_56_170 VGND VGND VPWR VPWR sky130_fd_sc_hd__decap_4
XFILLER_28_40 VGND VGND VPWR VPWR sky130_fd_sc_hd__decap_3
XFILLER_0_155 VGND VGND VPWR VPWR sky130_fd_sc_hd__fill_2
XFILLER_44_365 VPWR VGND VPWR VGND sky130_ef_sc_hd__decap_12
XTAP_TAPCELL_ROW_39_390 VGND VPWR sky130_fd_sc_hd__tapvpwrvgnd_1
XFILLER_8_299 VGND VGND VPWR VPWR sky130_fd_sc_hd__fill_2
X_1540_ clknet_leaf_24_clk_10mhz _0065_ net22 VGND VGND VPWR VPWR u_packet_assembler.timer\[20\]
+ sky130_fd_sc_hd__dfrtp_1
XFILLER_39_148 VGND VGND VPWR VPWR sky130_fd_sc_hd__decap_3
X_1471_ u_srf_ctrl.echo_counter\[12\] _0452_ VGND VGND VPWR VPWR _0453_ sky130_fd_sc_hd__and2_1
XFILLER_10_3 VPWR VGND VPWR VGND sky130_ef_sc_hd__decap_12
XFILLER_35_365 VPWR VGND VPWR VGND sky130_ef_sc_hd__decap_12
XFILLER_35_321 VGND VGND VPWR VPWR sky130_fd_sc_hd__decap_6
XFILLER_62_195 VGND VGND VPWR VPWR sky130_fd_sc_hd__fill_1
Xhold211 u_srf_ctrl.timer\[13\] VGND VGND VPWR VPWR net279 sky130_fd_sc_hd__dlygate4sd3_1
XPHY_EDGE_ROW_37_Left_101 VGND VGND VPWR VPWR sky130_fd_sc_hd__decap_3
X_1669_ clknet_leaf_15_clk_10mhz _0172_ VGND VGND VPWR VPWR u_fifo.mem\[3\]\[2\] sky130_fd_sc_hd__dfxtp_1
X_1738_ clknet_leaf_26_clk_10mhz _0241_ net53 VGND VGND VPWR VPWR distance_out\[5\]
+ sky130_fd_sc_hd__dfrtp_1
Xhold200 u_packet_assembler.timer\[8\] VGND VGND VPWR VPWR net268 sky130_fd_sc_hd__dlygate4sd3_1
XTAP_TAPCELL_ROW_28_316 VGND VPWR sky130_fd_sc_hd__tapvpwrvgnd_1
XFILLER_53_195 VGND VGND VPWR VPWR sky130_fd_sc_hd__decap_3
XFILLER_53_184 VGND VGND VPWR VPWR sky130_fd_sc_hd__decap_3
XFILLER_53_140 VGND VGND VPWR VPWR sky130_fd_sc_hd__decap_4
XPHY_EDGE_ROW_46_Left_110 VGND VGND VPWR VPWR sky130_fd_sc_hd__decap_3
XFILLER_41_346 VPWR VGND VPWR VGND sky130_ef_sc_hd__decap_12
XFILLER_41_335 VGND VGND VPWR VPWR sky130_fd_sc_hd__fill_1
XTAP_TAPCELL_ROW_36_371 VGND VPWR sky130_fd_sc_hd__tapvpwrvgnd_1
XFILLER_26_365 VPWR VGND VPWR VGND sky130_ef_sc_hd__decap_12
XFILLER_5_203 VGND VGND VPWR VPWR sky130_fd_sc_hd__fill_1
XFILLER_14_64 VGND VGND VPWR VPWR sky130_fd_sc_hd__decap_3
XFILLER_30_85 VGND VGND VPWR VPWR sky130_fd_sc_hd__fill_2
XFILLER_55_93 VGND VGND VPWR VPWR sky130_fd_sc_hd__fill_1
XFILLER_55_71 VGND VGND VPWR VPWR sky130_fd_sc_hd__fill_1
XFILLER_36_129 VGND VGND VPWR VPWR sky130_fd_sc_hd__fill_1
XFILLER_17_310 VGND VGND VPWR VPWR sky130_fd_sc_hd__decap_3
XFILLER_17_332 VGND VGND VPWR VPWR sky130_fd_sc_hd__decap_4
XFILLER_44_195 VGND VGND VPWR VPWR sky130_fd_sc_hd__fill_1
XFILLER_44_184 VGND VGND VPWR VPWR sky130_fd_sc_hd__fill_2
X_0971_ _0644_ VGND VGND VPWR VPWR _0645_ sky130_fd_sc_hd__inv_2
X_1523_ clknet_leaf_26_clk_10mhz _0048_ net20 VGND VGND VPWR VPWR u_packet_assembler.timer\[3\]
+ sky130_fd_sc_hd__dfrtp_1
X_1454_ net15 _0439_ _0441_ _0427_ u_srf_ctrl.echo_counter\[6\] VGND VGND VPWR VPWR
+ _0264_ sky130_fd_sc_hd__a32o_1
X_1385_ u_srf_ctrl.state\[3\] _0651_ _0652_ VGND VGND VPWR VPWR _0398_ sky130_fd_sc_hd__and3_1
XFILLER_35_173 VGND VGND VPWR VPWR sky130_fd_sc_hd__fill_1
XTAP_TAPCELL_ROW_33_352 VGND VPWR sky130_fd_sc_hd__tapvpwrvgnd_1
XFILLER_23_324 VPWR VGND VPWR VGND sky130_ef_sc_hd__decap_12
XFILLER_50_187 VGND VGND VPWR VPWR sky130_fd_sc_hd__decap_8
XTAP_TAPCELL_ROW_56_499 VGND VPWR sky130_fd_sc_hd__tapvpwrvgnd_1
XFILLER_41_187 VGND VGND VPWR VPWR sky130_fd_sc_hd__decap_8
XFILLER_41_154 VGND VGND VPWR VPWR sky130_fd_sc_hd__decap_8
XFILLER_25_96 VGND VGND VPWR VPWR sky130_fd_sc_hd__decap_4
XFILLER_49_221 VGND VGND VPWR VPWR sky130_fd_sc_hd__decap_3
X_1170_ net121 net37 _0741_ VGND VGND VPWR VPWR _0145_ sky130_fd_sc_hd__mux2_1
XFILLER_1_261 VPWR VGND VPWR VGND sky130_ef_sc_hd__decap_12
XTAP_TAPCELL_ROW_47_444 VGND VPWR sky130_fd_sc_hd__tapvpwrvgnd_1
XFILLER_17_140 VGND VGND VPWR VPWR sky130_fd_sc_hd__decap_4
X_0885_ u_srf_ctrl.timer\[8\] _0570_ VGND VGND VPWR VPWR _0572_ sky130_fd_sc_hd__xnor2_1
XTAP_TAPCELL_ROW_30_333 VGND VPWR sky130_fd_sc_hd__tapvpwrvgnd_1
XFILLER_9_361 VPWR VGND VPWR VGND sky130_ef_sc_hd__decap_12
X_0954_ _0626_ _0627_ VGND VGND VPWR VPWR _0628_ sky130_fd_sc_hd__xnor2_1
X_1506_ clknet_leaf_5_clk_10mhz _0032_ net58 VGND VGND VPWR VPWR u_srf_ctrl.timer\[10\]
+ sky130_fd_sc_hd__dfrtp_2
X_1437_ u_srf_ctrl.echo_counter\[2\] u_srf_ctrl.echo_counter\[1\] u_srf_ctrl.echo_counter\[0\]
+ VGND VGND VPWR VPWR _0429_ sky130_fd_sc_hd__and3_2
X_1368_ u_fifo.mem\[0\]\[7\] _0322_ _0388_ _0392_ VGND VGND VPWR VPWR _0393_ sky130_fd_sc_hd__o22a_1
XFILLER_55_279 VGND VGND VPWR VPWR sky130_fd_sc_hd__fill_1
X_1299_ _0303_ _0324_ _0308_ u_fifo.mem\[5\]\[1\] VGND VGND VPWR VPWR _0330_ sky130_fd_sc_hd__a2bb2o_1
XFILLER_11_54 VGND VGND VPWR VPWR sky130_fd_sc_hd__fill_2
XFILLER_46_246 VGND VGND VPWR VPWR sky130_fd_sc_hd__decap_6
XTAP_TAPCELL_ROW_44_425 VGND VPWR sky130_fd_sc_hd__tapvpwrvgnd_1
XFILLER_52_72 VPWR VGND VPWR VGND sky130_ef_sc_hd__decap_12
X_1222_ net197 net42 _0283_ VGND VGND VPWR VPWR _0190_ sky130_fd_sc_hd__mux2_1
X_1084_ u_packet_assembler.state\[0\] u_packet_assembler.state\[1\] _0714_ _0547_
+ VGND VGND VPWR VPWR _0715_ sky130_fd_sc_hd__a31o_1
X_1153_ net117 net51 _0739_ VGND VGND VPWR VPWR _0130_ sky130_fd_sc_hd__mux2_1
X_0799_ _0480_ _0512_ VGND VGND VPWR VPWR _0513_ sky130_fd_sc_hd__nor2_1
X_0937_ net27 net28 _0610_ VGND VGND VPWR VPWR _0611_ sky130_fd_sc_hd__and3_1
X_0868_ _0552_ _0559_ _0560_ VGND VGND VPWR VPWR _0024_ sky130_fd_sc_hd__and3_1
XTAP_TAPCELL_ROW_58_517 VGND VPWR sky130_fd_sc_hd__tapvpwrvgnd_1
XFILLER_28_213 VGND VGND VPWR VPWR sky130_fd_sc_hd__fill_1
XFILLER_28_257 VGND VGND VPWR VPWR sky130_fd_sc_hd__fill_1
XTAP_TAPCELL_ROW_41_406 VGND VPWR sky130_fd_sc_hd__tapvpwrvgnd_1
XFILLER_11_113 VGND VGND VPWR VPWR sky130_fd_sc_hd__fill_2
XFILLER_11_135 VGND VGND VPWR VPWR sky130_fd_sc_hd__fill_1
XFILLER_19_268 VPWR VGND VPWR VGND sky130_ef_sc_hd__decap_12
X_1771_ clknet_leaf_3_clk_10mhz net14 net61 VGND VGND VPWR VPWR fifo_rd_en sky130_fd_sc_hd__dfrtp_1
XFILLER_40_3 VGND VGND VPWR VPWR sky130_fd_sc_hd__decap_6
XTAP_TAPCELL_ROW_63_553 VGND VPWR sky130_fd_sc_hd__tapvpwrvgnd_1
X_1136_ net46 net174 _0736_ VGND VGND VPWR VPWR _0116_ sky130_fd_sc_hd__mux2_1
X_1067_ net46 net166 _0712_ VGND VGND VPWR VPWR _0071_ sky130_fd_sc_hd__mux2_1
X_1205_ net198 net40 _0281_ VGND VGND VPWR VPWR _0175_ sky130_fd_sc_hd__mux2_1
XFILLER_40_219 VGND VGND VPWR VPWR sky130_fd_sc_hd__decap_6
XFILLER_0_337 VPWR VGND VPWR VGND sky130_ef_sc_hd__decap_12
XFILLER_56_341 VPWR VGND VPWR VGND sky130_ef_sc_hd__decap_12
XFILLER_17_42 VGND VGND VPWR VPWR sky130_fd_sc_hd__decap_3
XFILLER_58_82 VGND VGND VPWR VPWR sky130_fd_sc_hd__fill_2
Xhold4 u_fifo.mem\[5\]\[1\] VGND VGND VPWR VPWR net72 sky130_fd_sc_hd__dlygate4sd3_1
XFILLER_3_175 VPWR VGND VPWR VGND sky130_ef_sc_hd__decap_12
XFILLER_62_333 VPWR VGND VPWR VGND sky130_ef_sc_hd__decap_12
XFILLER_47_374 VGND VGND VPWR VPWR sky130_fd_sc_hd__decap_3
XFILLER_30_285 VGND VGND VPWR VPWR sky130_fd_sc_hd__fill_2
XFILLER_15_293 VGND VGND VPWR VPWR sky130_fd_sc_hd__decap_6
X_1754_ clknet_leaf_7_clk_10mhz _0257_ net64 VGND VGND VPWR VPWR net8 sky130_fd_sc_hd__dfstp_1
XPHY_EDGE_ROW_29_Left_93 VGND VGND VPWR VPWR sky130_fd_sc_hd__decap_3
X_1685_ clknet_leaf_18_clk_10mhz _0188_ VGND VGND VPWR VPWR u_fifo.mem\[2\]\[2\] sky130_fd_sc_hd__dfxtp_1
XFILLER_38_363 VGND VGND VPWR VPWR sky130_fd_sc_hd__fill_1
XPHY_EDGE_ROW_13_Left_77 VGND VGND VPWR VPWR sky130_fd_sc_hd__decap_3
X_1119_ net42 net159 _0733_ VGND VGND VPWR VPWR _0102_ sky130_fd_sc_hd__mux2_1
XTAP_TAPCELL_ROW_0_134 VGND VPWR sky130_fd_sc_hd__tapvpwrvgnd_1
XPHY_EDGE_ROW_17_Right_17 VGND VGND VPWR VPWR sky130_fd_sc_hd__decap_3
XPHY_EDGE_ROW_26_Right_26 VGND VGND VPWR VPWR sky130_fd_sc_hd__decap_3
XFILLER_48_138 VGND VGND VPWR VPWR sky130_fd_sc_hd__fill_2
XFILLER_44_344 VPWR VGND VPWR VGND sky130_ef_sc_hd__decap_12
XFILLER_44_300 VGND VGND VPWR VPWR sky130_fd_sc_hd__fill_1
XTAP_TAPCELL_ROW_39_391 VGND VPWR sky130_fd_sc_hd__tapvpwrvgnd_1
XFILLER_28_96 VGND VGND VPWR VPWR sky130_fd_sc_hd__decap_8
XFILLER_28_85 VGND VGND VPWR VPWR sky130_fd_sc_hd__decap_6
XPHY_EDGE_ROW_35_Right_35 VGND VGND VPWR VPWR sky130_fd_sc_hd__decap_3
XTAP_TAPCELL_ROW_14_225 VGND VPWR sky130_fd_sc_hd__tapvpwrvgnd_1
XFILLER_60_61 VPWR VGND VPWR VGND sky130_ef_sc_hd__decap_12
X_1470_ _0618_ _0632_ _0443_ VGND VGND VPWR VPWR _0452_ sky130_fd_sc_hd__and3_1
XTAP_TAPCELL_ROW_22_280 VGND VPWR sky130_fd_sc_hd__tapvpwrvgnd_1
XPHY_EDGE_ROW_44_Right_44 VGND VGND VPWR VPWR sky130_fd_sc_hd__decap_3
XPHY_EDGE_ROW_53_Right_53 VGND VGND VPWR VPWR sky130_fd_sc_hd__decap_3
Xhold201 u_fifo.wr_ptr\[2\] VGND VGND VPWR VPWR net269 sky130_fd_sc_hd__dlygate4sd3_1
XPHY_EDGE_ROW_62_Right_62 VGND VGND VPWR VPWR sky130_fd_sc_hd__decap_3
X_1668_ clknet_leaf_15_clk_10mhz _0171_ VGND VGND VPWR VPWR u_fifo.mem\[3\]\[1\] sky130_fd_sc_hd__dfxtp_1
X_1599_ clknet_leaf_17_clk_10mhz _0102_ VGND VGND VPWR VPWR u_fifo.mem\[11\]\[4\]
+ sky130_fd_sc_hd__dfxtp_1
X_1737_ clknet_leaf_26_clk_10mhz _0240_ net53 VGND VGND VPWR VPWR distance_out\[4\]
+ sky130_fd_sc_hd__dfrtp_1
Xhold212 u_max30102_ctrl.clk_div\[13\] VGND VGND VPWR VPWR net280 sky130_fd_sc_hd__dlygate4sd3_1
XTAP_TAPCELL_ROW_28_317 VGND VPWR sky130_fd_sc_hd__tapvpwrvgnd_1
XFILLER_41_358 VPWR VGND VPWR VGND sky130_ef_sc_hd__decap_12
XTAP_TAPCELL_ROW_36_372 VGND VPWR sky130_fd_sc_hd__tapvpwrvgnd_1
XTAP_TAPCELL_ROW_11_206 VGND VPWR sky130_fd_sc_hd__tapvpwrvgnd_1
XFILLER_14_43 VGND VGND VPWR VPWR sky130_fd_sc_hd__fill_1
XFILLER_44_141 VPWR VGND VPWR VGND sky130_ef_sc_hd__decap_12
X_0970_ _0640_ _0643_ VGND VGND VPWR VPWR _0644_ sky130_fd_sc_hd__or2_1
X_1522_ clknet_leaf_26_clk_10mhz _0047_ net20 VGND VGND VPWR VPWR u_packet_assembler.timer\[2\]
+ sky130_fd_sc_hd__dfrtp_1
X_1453_ _0440_ VGND VGND VPWR VPWR _0441_ sky130_fd_sc_hd__inv_2
X_1384_ _0469_ _0650_ _0653_ _0397_ VGND VGND VPWR VPWR _0238_ sky130_fd_sc_hd__o31ai_1
XFILLER_50_100 VGND VGND VPWR VPWR sky130_fd_sc_hd__decap_3
XFILLER_35_196 VGND VGND VPWR VPWR sky130_fd_sc_hd__fill_1
XTAP_TAPCELL_ROW_33_353 VGND VPWR sky130_fd_sc_hd__tapvpwrvgnd_1
XFILLER_58_233 VGND VGND VPWR VPWR sky130_fd_sc_hd__fill_2
XPHY_EDGE_ROW_16_Left_80 VGND VGND VPWR VPWR sky130_fd_sc_hd__decap_3
XFILLER_25_31 VPWR VGND VPWR VGND sky130_ef_sc_hd__decap_12
XFILLER_41_133 VGND VGND VPWR VPWR sky130_fd_sc_hd__fill_1
XTAP_TAPCELL_ROW_47_445 VGND VPWR sky130_fd_sc_hd__tapvpwrvgnd_1
XFILLER_1_273 VGND VGND VPWR VPWR sky130_fd_sc_hd__decap_6
XFILLER_32_155 VGND VGND VPWR VPWR sky130_fd_sc_hd__decap_8
XFILLER_17_152 VGND VGND VPWR VPWR sky130_fd_sc_hd__decap_3
X_0884_ net10 _0570_ _0571_ net19 net275 VGND VGND VPWR VPWR _0029_ sky130_fd_sc_hd__a32o_1
XTAP_TAPCELL_ROW_30_334 VGND VPWR sky130_fd_sc_hd__tapvpwrvgnd_1
XFILLER_9_373 VGND VGND VPWR VPWR sky130_fd_sc_hd__decap_4
X_0953_ u_srf_ctrl.echo_counter\[10\] u_srf_ctrl.echo_counter\[6\] VGND VGND VPWR
+ VPWR _0627_ sky130_fd_sc_hd__nand2_1
X_1367_ u_fifo.mem\[10\]\[7\] _0307_ _0389_ _0391_ VGND VGND VPWR VPWR _0392_ sky130_fd_sc_hd__a211o_1
X_1505_ clknet_leaf_3_clk_10mhz _0031_ net58 VGND VGND VPWR VPWR u_srf_ctrl.timer\[9\]
+ sky130_fd_sc_hd__dfrtp_1
X_1436_ _0497_ net15 _0428_ _0427_ u_srf_ctrl.echo_counter\[1\] VGND VGND VPWR VPWR
+ _0259_ sky130_fd_sc_hd__a32o_1
X_1298_ u_fifo.mem\[1\]\[1\] _0302_ _0313_ u_fifo.mem\[3\]\[1\] VGND VGND VPWR VPWR
+ _0329_ sky130_fd_sc_hd__a22o_1
XFILLER_62_29 VPWR VGND VPWR VGND sky130_ef_sc_hd__decap_12
XFILLER_11_306 VGND VGND VPWR VPWR sky130_fd_sc_hd__fill_2
XFILLER_23_155 VGND VGND VPWR VPWR sky130_fd_sc_hd__decap_8
XFILLER_11_11 VGND VGND VPWR VPWR sky130_fd_sc_hd__fill_2
XFILLER_61_239 VGND VGND VPWR VPWR sky130_fd_sc_hd__decap_3
XFILLER_54_291 VGND VGND VPWR VPWR sky130_fd_sc_hd__fill_1
XTAP_TAPCELL_ROW_44_426 VGND VPWR sky130_fd_sc_hd__tapvpwrvgnd_1
XFILLER_36_85 VGND VGND VPWR VPWR sky130_fd_sc_hd__fill_1
XFILLER_36_52 VGND VGND VPWR VPWR sky130_fd_sc_hd__decap_3
XPHY_EDGE_ROW_1_Left_65 VGND VGND VPWR VPWR sky130_fd_sc_hd__decap_3
XFILLER_6_365 VPWR VGND VPWR VGND sky130_ef_sc_hd__decap_12
XFILLER_10_350 VPWR VGND VPWR VGND sky130_ef_sc_hd__decap_12
XFILLER_42_7 VPWR VGND VPWR VGND sky130_ef_sc_hd__decap_12
X_1221_ net98 net44 _0283_ VGND VGND VPWR VPWR _0189_ sky130_fd_sc_hd__mux2_1
XFILLER_37_225 VGND VGND VPWR VPWR sky130_fd_sc_hd__fill_1
X_1152_ net30 net29 _0709_ _0711_ VGND VGND VPWR VPWR _0739_ sky130_fd_sc_hd__and4b_4
X_1083_ u_packet_assembler.state\[3\] _0478_ VGND VGND VPWR VPWR _0714_ sky130_fd_sc_hd__nor2_1
XFILLER_60_250 VGND VGND VPWR VPWR sky130_fd_sc_hd__fill_2
X_0936_ u_srf_ctrl.echo_counter\[8\] u_srf_ctrl.echo_counter\[4\] VGND VGND VPWR VPWR
+ _0610_ sky130_fd_sc_hd__xor2_1
XFILLER_20_147 VGND VGND VPWR VPWR sky130_fd_sc_hd__decap_4
X_0798_ u_srf_ctrl.timer\[14\] u_srf_ctrl.timer\[9\] u_srf_ctrl.timer\[5\] u_srf_ctrl.timer\[4\]
+ VGND VGND VPWR VPWR _0512_ sky130_fd_sc_hd__or4_1
X_0867_ u_srf_ctrl.timer\[2\] _0557_ VGND VGND VPWR VPWR _0560_ sky130_fd_sc_hd__or2_1
XFILLER_57_29 VGND VGND VPWR VPWR sky130_fd_sc_hd__fill_1
X_1419_ net226 _0493_ VGND VGND VPWR VPWR _0254_ sky130_fd_sc_hd__and2_1
XFILLER_7_129 VGND VGND VPWR VPWR sky130_fd_sc_hd__fill_1
XFILLER_3_302 VPWR VGND VPWR VGND sky130_ef_sc_hd__decap_12
XFILLER_11_169 VPWR VGND VPWR VGND sky130_ef_sc_hd__decap_12
XFILLER_0_3 VPWR VGND VPWR VGND sky130_ef_sc_hd__decap_12
XFILLER_59_361 VPWR VGND VPWR VGND sky130_ef_sc_hd__decap_12
XTAP_TAPCELL_ROW_6_173 VGND VPWR sky130_fd_sc_hd__tapvpwrvgnd_1
XFILLER_19_203 VPWR VGND VPWR VGND sky130_ef_sc_hd__decap_12
XFILLER_19_225 VGND VGND VPWR VPWR sky130_fd_sc_hd__fill_1
X_1770_ clknet_leaf_27_clk_10mhz _0273_ net52 VGND VGND VPWR VPWR u_srf_ctrl.echo_counter\[15\]
+ sky130_fd_sc_hd__dfrtp_1
X_1204_ net150 net42 _0281_ VGND VGND VPWR VPWR _0174_ sky130_fd_sc_hd__mux2_1
XTAP_TAPCELL_ROW_63_554 VGND VPWR sky130_fd_sc_hd__tapvpwrvgnd_1
X_1066_ net48 net203 _0712_ VGND VGND VPWR VPWR _0070_ sky130_fd_sc_hd__mux2_1
X_1135_ net49 net215 _0736_ VGND VGND VPWR VPWR _0115_ sky130_fd_sc_hd__mux2_1
XFILLER_40_209 VGND VGND VPWR VPWR sky130_fd_sc_hd__fill_1
XFILLER_33_294 VGND VGND VPWR VPWR sky130_fd_sc_hd__decap_4
X_0919_ u_srf_ctrl.timer\[18\] u_srf_ctrl.timer\[17\] u_srf_ctrl.timer\[16\] _0588_
+ VGND VGND VPWR VPWR _0596_ sky130_fd_sc_hd__and4_1
XFILLER_0_349 VPWR VGND VPWR VGND sky130_ef_sc_hd__decap_12
XFILLER_0_305 VGND VGND VPWR VPWR sky130_fd_sc_hd__decap_3
XFILLER_56_353 VGND VGND VPWR VPWR sky130_fd_sc_hd__decap_8
XFILLER_48_309 VGND VGND VPWR VPWR sky130_fd_sc_hd__decap_6
XTAP_TAPCELL_ROW_3_154 VGND VPWR sky130_fd_sc_hd__tapvpwrvgnd_1
XFILLER_3_187 VGND VGND VPWR VPWR sky130_fd_sc_hd__decap_8
XFILLER_3_165 VGND VGND VPWR VPWR sky130_fd_sc_hd__decap_3
Xhold5 u_fifo.mem\[14\]\[2\] VGND VGND VPWR VPWR net73 sky130_fd_sc_hd__dlygate4sd3_1
XFILLER_62_345 VPWR VGND VPWR VGND sky130_ef_sc_hd__decap_12
XTAP_TAPCELL_ROW_17_245 VGND VPWR sky130_fd_sc_hd__tapvpwrvgnd_1
XTAP_TAPCELL_ROW_60_524 VGND VPWR sky130_fd_sc_hd__tapvpwrvgnd_1
X_1753_ clknet_leaf_5_clk_10mhz _0256_ net59 VGND VGND VPWR VPWR u_uart.clk_count\[13\]
+ sky130_fd_sc_hd__dfrtp_1
X_1684_ clknet_leaf_18_clk_10mhz _0187_ VGND VGND VPWR VPWR u_fifo.mem\[2\]\[1\] sky130_fd_sc_hd__dfxtp_1
XTAP_TAPCELL_ROW_0_135 VGND VPWR sky130_fd_sc_hd__tapvpwrvgnd_1
X_1118_ net45 net188 _0733_ VGND VGND VPWR VPWR _0101_ sky130_fd_sc_hd__mux2_1
X_1049_ _0705_ _0706_ VGND VGND VPWR VPWR _0059_ sky130_fd_sc_hd__nor2_1
XFILLER_0_113 VPWR VGND VPWR VGND sky130_ef_sc_hd__decap_12
XFILLER_44_356 VGND VGND VPWR VPWR sky130_fd_sc_hd__decap_8
XFILLER_44_323 VPWR VGND VPWR VGND sky130_ef_sc_hd__decap_12
XTAP_TAPCELL_ROW_39_392 VGND VPWR sky130_fd_sc_hd__tapvpwrvgnd_1
XFILLER_60_73 VGND VGND VPWR VPWR sky130_fd_sc_hd__decap_8
XFILLER_44_85 VGND VGND VPWR VPWR sky130_fd_sc_hd__decap_8
XFILLER_44_74 VGND VGND VPWR VPWR sky130_fd_sc_hd__fill_1
XPHY_EDGE_ROW_30_Left_94 VGND VGND VPWR VPWR sky130_fd_sc_hd__decap_3
XFILLER_8_268 VGND VGND VPWR VPWR sky130_fd_sc_hd__decap_3
XFILLER_8_279 VPWR VGND VPWR VGND sky130_ef_sc_hd__decap_12
XFILLER_12_253 VGND VGND VPWR VPWR sky130_fd_sc_hd__decap_6
XTAP_TAPCELL_ROW_14_226 VGND VPWR sky130_fd_sc_hd__tapvpwrvgnd_1
XTAP_TAPCELL_ROW_22_281 VGND VPWR sky130_fd_sc_hd__tapvpwrvgnd_1
Xclkbuf_leaf_2_clk_10mhz clknet_2_0__leaf_clk_10mhz VGND VGND VPWR VPWR clknet_leaf_2_clk_10mhz
+ sky130_fd_sc_hd__clkbuf_8
XFILLER_5_57 VPWR VGND VPWR VGND sky130_ef_sc_hd__decap_12
XFILLER_62_197 VGND VGND VPWR VPWR sky130_fd_sc_hd__fill_2
Xhold202 u_srf_ctrl.timer\[6\] VGND VGND VPWR VPWR net270 sky130_fd_sc_hd__dlygate4sd3_1
Xhold213 u_max30102_ctrl.clk_div\[10\] VGND VGND VPWR VPWR net281 sky130_fd_sc_hd__dlygate4sd3_1
X_1736_ clknet_leaf_2_clk_10mhz _0239_ net56 VGND VGND VPWR VPWR distance_out\[3\]
+ sky130_fd_sc_hd__dfrtp_1
X_1667_ clknet_leaf_8_clk_10mhz _0170_ VGND VGND VPWR VPWR u_fifo.mem\[3\]\[0\] sky130_fd_sc_hd__dfxtp_1
X_1598_ clknet_leaf_11_clk_10mhz _0101_ VGND VGND VPWR VPWR u_fifo.mem\[11\]\[3\]
+ sky130_fd_sc_hd__dfxtp_1
XFILLER_53_164 VGND VGND VPWR VPWR sky130_fd_sc_hd__decap_4
XFILLER_45_109 VGND VGND VPWR VPWR sky130_fd_sc_hd__decap_3
XTAP_TAPCELL_ROW_28_318 VGND VPWR sky130_fd_sc_hd__tapvpwrvgnd_1
XTAP_TAPCELL_ROW_36_373 VGND VPWR sky130_fd_sc_hd__tapvpwrvgnd_1
XTAP_TAPCELL_ROW_11_207 VGND VPWR sky130_fd_sc_hd__tapvpwrvgnd_1
XFILLER_14_11 VGND VGND VPWR VPWR sky130_fd_sc_hd__fill_2
XFILLER_44_153 VPWR VGND VPWR VGND sky130_ef_sc_hd__decap_12
X_1521_ clknet_leaf_26_clk_10mhz _0046_ net20 VGND VGND VPWR VPWR u_packet_assembler.timer\[1\]
+ sky130_fd_sc_hd__dfrtp_1
X_1383_ _0469_ net241 VGND VGND VPWR VPWR _0397_ sky130_fd_sc_hd__nand2_1
X_1452_ u_srf_ctrl.echo_counter\[6\] _0437_ VGND VGND VPWR VPWR _0440_ sky130_fd_sc_hd__and2_1
XFILLER_50_123 VGND VGND VPWR VPWR sky130_fd_sc_hd__decap_4
XTAP_TAPCELL_ROW_33_354 VGND VPWR sky130_fd_sc_hd__tapvpwrvgnd_1
XFILLER_23_337 VPWR VGND VPWR VGND sky130_ef_sc_hd__decap_12
X_1719_ clknet_leaf_7_clk_10mhz _0222_ VGND VGND VPWR VPWR fifo_dout\[2\] sky130_fd_sc_hd__dfxtp_1
XFILLER_58_289 VGND VGND VPWR VPWR sky130_fd_sc_hd__fill_1
XFILLER_18_109 VPWR VGND VPWR VGND sky130_ef_sc_hd__decap_12
XFILLER_26_120 VPWR VGND VPWR VGND sky130_ef_sc_hd__decap_12
XFILLER_25_43 VPWR VGND VPWR VGND sky130_ef_sc_hd__decap_12
XFILLER_49_278 VGND VGND VPWR VPWR sky130_fd_sc_hd__fill_2
XTAP_TAPCELL_ROW_30_335 VGND VPWR sky130_fd_sc_hd__tapvpwrvgnd_1
X_0952_ u_srf_ctrl.echo_counter\[11\] net27 VGND VGND VPWR VPWR _0626_ sky130_fd_sc_hd__xnor2_1
XFILLER_20_307 VGND VGND VPWR VPWR sky130_fd_sc_hd__fill_1
XFILLER_63_3 VPWR VGND VPWR VGND sky130_ef_sc_hd__decap_12
X_1504_ clknet_leaf_3_clk_10mhz _0030_ net58 VGND VGND VPWR VPWR u_srf_ctrl.timer\[8\]
+ sky130_fd_sc_hd__dfrtp_2
X_0883_ u_srf_ctrl.timer\[7\] _0567_ VGND VGND VPWR VPWR _0571_ sky130_fd_sc_hd__or2_1
X_1366_ u_fifo.mem\[1\]\[7\] _0302_ _0305_ u_fifo.mem\[7\]\[7\] _0390_ VGND VGND VPWR
+ VPWR _0391_ sky130_fd_sc_hd__a221o_1
X_1435_ u_srf_ctrl.echo_counter\[1\] u_srf_ctrl.echo_counter\[0\] VGND VGND VPWR VPWR
+ _0428_ sky130_fd_sc_hd__nand2_1
XFILLER_63_281 VPWR VGND VPWR VGND sky130_ef_sc_hd__decap_12
X_1297_ u_fifo.mem\[8\]\[1\] _0300_ _0311_ u_fifo.mem\[4\]\[1\] _0327_ VGND VGND VPWR
+ VPWR _0328_ sky130_fd_sc_hd__a221o_1
XFILLER_23_167 VGND VGND VPWR VPWR sky130_fd_sc_hd__fill_1
XFILLER_23_189 VGND VGND VPWR VPWR sky130_fd_sc_hd__fill_1
XFILLER_11_45 VGND VGND VPWR VPWR sky130_fd_sc_hd__decap_6
XFILLER_46_237 VGND VGND VPWR VPWR sky130_fd_sc_hd__fill_1
XFILLER_36_64 VGND VGND VPWR VPWR sky130_fd_sc_hd__decap_4
XFILLER_61_229 VGND VGND VPWR VPWR sky130_fd_sc_hd__fill_1
XFILLER_36_75 VGND VGND VPWR VPWR sky130_fd_sc_hd__fill_1
XFILLER_6_344 VPWR VGND VPWR VGND sky130_ef_sc_hd__decap_12
XFILLER_10_362 VGND VGND VPWR VPWR sky130_fd_sc_hd__fill_2
X_1151_ net115 net36 _0738_ VGND VGND VPWR VPWR _0129_ sky130_fd_sc_hd__mux2_1
XTAP_TAPCELL_ROW_9_193 VGND VPWR sky130_fd_sc_hd__tapvpwrvgnd_1
X_1220_ net80 net46 _0283_ VGND VGND VPWR VPWR _0188_ sky130_fd_sc_hd__mux2_1
XFILLER_52_218 VGND VGND VPWR VPWR sky130_fd_sc_hd__decap_3
XFILLER_52_207 VGND VGND VPWR VPWR sky130_fd_sc_hd__fill_2
XFILLER_45_281 VGND VGND VPWR VPWR sky130_fd_sc_hd__decap_6
X_1082_ _0546_ _0664_ VGND VGND VPWR VPWR _0713_ sky130_fd_sc_hd__nor2_2
X_0866_ u_srf_ctrl.timer\[2\] _0557_ VGND VGND VPWR VPWR _0559_ sky130_fd_sc_hd__nand2_1
X_0935_ u_srf_ctrl.echo_counter\[8\] u_srf_ctrl.echo_counter\[4\] VGND VGND VPWR VPWR
+ _0609_ sky130_fd_sc_hd__nand2_1
X_0797_ u_srf_ctrl.state\[1\] _0511_ VGND VGND VPWR VPWR _0003_ sky130_fd_sc_hd__and2_1
X_1349_ u_fifo.mem\[15\]\[6\] _0291_ _0309_ u_fifo.mem\[9\]\[6\] VGND VGND VPWR VPWR
+ _0375_ sky130_fd_sc_hd__a22o_1
X_1418_ net223 _0493_ VGND VGND VPWR VPWR _0253_ sky130_fd_sc_hd__and2_1
XFILLER_36_292 VGND VGND VPWR VPWR sky130_fd_sc_hd__fill_1
XFILLER_36_270 VGND VGND VPWR VPWR sky130_fd_sc_hd__decap_6
XFILLER_11_104 VGND VGND VPWR VPWR sky130_fd_sc_hd__fill_2
XFILLER_3_325 VGND VGND VPWR VPWR sky130_fd_sc_hd__decap_8
XFILLER_3_314 VGND VGND VPWR VPWR sky130_fd_sc_hd__decap_3
XFILLER_22_11 VGND VGND VPWR VPWR sky130_fd_sc_hd__fill_2
XFILLER_59_373 VGND VGND VPWR VPWR sky130_fd_sc_hd__decap_4
XTAP_TAPCELL_ROW_6_174 VGND VPWR sky130_fd_sc_hd__tapvpwrvgnd_1
XFILLER_34_218 VGND VGND VPWR VPWR sky130_fd_sc_hd__fill_1
XFILLER_27_281 VGND VGND VPWR VPWR sky130_fd_sc_hd__decap_4
XFILLER_19_215 VGND VGND VPWR VPWR sky130_fd_sc_hd__decap_8
XFILLER_42_262 VGND VGND VPWR VPWR sky130_fd_sc_hd__fill_2
XFILLER_42_251 VGND VGND VPWR VPWR sky130_fd_sc_hd__fill_1
XFILLER_6_141 VPWR VGND VPWR VGND sky130_ef_sc_hd__decap_12
X_1203_ net144 net45 _0281_ VGND VGND VPWR VPWR _0173_ sky130_fd_sc_hd__mux2_1
X_1134_ net50 net196 _0736_ VGND VGND VPWR VPWR _0114_ sky130_fd_sc_hd__mux2_1
XTAP_TAPCELL_ROW_63_555 VGND VPWR sky130_fd_sc_hd__tapvpwrvgnd_1
XTAP_TAPCELL_ROW_63_544 VGND VPWR sky130_fd_sc_hd__tapvpwrvgnd_1
X_1065_ net50 net175 _0712_ VGND VGND VPWR VPWR _0069_ sky130_fd_sc_hd__mux2_1
XFILLER_18_281 VPWR VGND VPWR VGND sky130_ef_sc_hd__decap_12
X_0918_ u_srf_ctrl.timer\[18\] _0476_ _0553_ VGND VGND VPWR VPWR _0595_ sky130_fd_sc_hd__and3_1
X_0849_ u_packet_assembler.state\[1\] u_packet_assembler.state\[2\] u_packet_assembler.state\[3\]
+ VGND VGND VPWR VPWR _0545_ sky130_fd_sc_hd__o21ba_1
XFILLER_56_365 VPWR VGND VPWR VGND sky130_ef_sc_hd__decap_12
XTAP_TAPCELL_ROW_3_155 VGND VPWR sky130_fd_sc_hd__tapvpwrvgnd_1
XFILLER_17_55 VGND VGND VPWR VPWR sky130_fd_sc_hd__fill_1
XFILLER_33_76 VGND VGND VPWR VPWR sky130_fd_sc_hd__decap_8
XFILLER_3_100 VPWR VGND VPWR VGND sky130_ef_sc_hd__decap_12
XFILLER_58_73 VGND VGND VPWR VPWR sky130_fd_sc_hd__fill_1
XFILLER_47_354 VPWR VGND VPWR VGND sky130_ef_sc_hd__decap_12
Xhold6 u_fifo.mem\[6\]\[2\] VGND VGND VPWR VPWR net74 sky130_fd_sc_hd__dlygate4sd3_1
XFILLER_62_357 VGND VGND VPWR VPWR sky130_fd_sc_hd__decap_6
XTAP_TAPCELL_ROW_60_525 VGND VPWR sky130_fd_sc_hd__tapvpwrvgnd_1
XFILLER_30_221 VGND VGND VPWR VPWR sky130_fd_sc_hd__decap_4
XTAP_TAPCELL_ROW_17_246 VGND VPWR sky130_fd_sc_hd__tapvpwrvgnd_1
X_1752_ clknet_leaf_5_clk_10mhz _0255_ net62 VGND VGND VPWR VPWR u_uart.clk_count\[12\]
+ sky130_fd_sc_hd__dfrtp_1
X_1683_ clknet_leaf_24_clk_10mhz _0186_ VGND VGND VPWR VPWR u_fifo.mem\[2\]\[0\] sky130_fd_sc_hd__dfxtp_1
XFILLER_38_365 VPWR VGND VPWR VGND sky130_ef_sc_hd__decap_12
XFILLER_38_332 VGND VGND VPWR VPWR sky130_fd_sc_hd__decap_3
X_1117_ net46 net164 _0733_ VGND VGND VPWR VPWR _0100_ sky130_fd_sc_hd__mux2_1
XTAP_TAPCELL_ROW_0_136 VGND VPWR sky130_fd_sc_hd__tapvpwrvgnd_1
XPHY_EDGE_ROW_3_Right_3 VGND VGND VPWR VPWR sky130_fd_sc_hd__decap_3
X_1048_ net267 net17 _0704_ VGND VGND VPWR VPWR _0706_ sky130_fd_sc_hd__a21oi_1
XFILLER_21_265 VPWR VGND VPWR VGND sky130_ef_sc_hd__decap_12
XFILLER_0_147 VGND VGND VPWR VPWR sky130_fd_sc_hd__decap_8
XFILLER_0_125 VPWR VGND VPWR VGND sky130_ef_sc_hd__decap_12
XFILLER_0_169 VPWR VGND VPWR VGND sky130_ef_sc_hd__decap_12
XFILLER_56_184 VGND VGND VPWR VPWR sky130_fd_sc_hd__decap_4
XTAP_TAPCELL_ROW_39_393 VGND VPWR sky130_fd_sc_hd__tapvpwrvgnd_1
XTAP_TAPCELL_ROW_14_227 VGND VPWR sky130_fd_sc_hd__tapvpwrvgnd_1
XFILLER_60_85 VPWR VGND VPWR VGND sky130_ef_sc_hd__decap_12
XTAP_TAPCELL_ROW_22_282 VGND VPWR sky130_fd_sc_hd__tapvpwrvgnd_1
Xclkbuf_leaf_6_clk_10mhz clknet_2_1__leaf_clk_10mhz VGND VGND VPWR VPWR clknet_leaf_6_clk_10mhz
+ sky130_fd_sc_hd__clkbuf_8
XFILLER_5_69 VGND VGND VPWR VPWR sky130_fd_sc_hd__fill_1
XFILLER_62_187 VGND VGND VPWR VPWR sky130_fd_sc_hd__decap_8
X_1666_ clknet_leaf_14_clk_10mhz _0169_ VGND VGND VPWR VPWR u_fifo.mem\[4\]\[7\] sky130_fd_sc_hd__dfxtp_1
Xhold203 u_uart.clk_count\[6\] VGND VGND VPWR VPWR net271 sky130_fd_sc_hd__dlygate4sd3_1
X_1735_ clknet_leaf_26_clk_10mhz _0238_ net53 VGND VGND VPWR VPWR distance_out\[2\]
+ sky130_fd_sc_hd__dfrtp_1
X_1597_ clknet_leaf_15_clk_10mhz _0100_ VGND VGND VPWR VPWR u_fifo.mem\[11\]\[2\]
+ sky130_fd_sc_hd__dfxtp_1
XFILLER_38_195 VGND VGND VPWR VPWR sky130_fd_sc_hd__fill_1
XFILLER_38_162 VGND VGND VPWR VPWR sky130_fd_sc_hd__decap_3
XTAP_TAPCELL_ROW_36_374 VGND VPWR sky130_fd_sc_hd__tapvpwrvgnd_1
XTAP_TAPCELL_ROW_28_319 VGND VPWR sky130_fd_sc_hd__tapvpwrvgnd_1
XFILLER_26_335 VPWR VGND VPWR VGND sky130_ef_sc_hd__decap_12
XTAP_TAPCELL_ROW_11_208 VGND VPWR sky130_fd_sc_hd__tapvpwrvgnd_1
XFILLER_14_56 VGND VGND VPWR VPWR sky130_fd_sc_hd__decap_8
XFILLER_30_44 VGND VGND VPWR VPWR sky130_fd_sc_hd__fill_1
XFILLER_29_151 VGND VGND VPWR VPWR sky130_fd_sc_hd__decap_3
XFILLER_44_176 VGND VGND VPWR VPWR sky130_fd_sc_hd__decap_8
XFILLER_44_165 VGND VGND VPWR VPWR sky130_fd_sc_hd__fill_2
X_1520_ clknet_leaf_26_clk_10mhz _0045_ net20 VGND VGND VPWR VPWR u_packet_assembler.timer\[0\]
+ sky130_fd_sc_hd__dfrtp_2
X_1382_ _0469_ _0655_ _0656_ _0396_ VGND VGND VPWR VPWR _0237_ sky130_fd_sc_hd__o31ai_1
X_1451_ u_srf_ctrl.echo_counter\[6\] _0437_ VGND VGND VPWR VPWR _0439_ sky130_fd_sc_hd__or2_1
XFILLER_50_157 VGND VGND VPWR VPWR sky130_fd_sc_hd__fill_1
XFILLER_23_349 VPWR VGND VPWR VGND sky130_ef_sc_hd__decap_12
X_1718_ clknet_leaf_9_clk_10mhz _0221_ VGND VGND VPWR VPWR fifo_dout\[1\] sky130_fd_sc_hd__dfxtp_1
X_1649_ clknet_leaf_17_clk_10mhz _0152_ VGND VGND VPWR VPWR u_fifo.mem\[6\]\[6\] sky130_fd_sc_hd__dfxtp_1
XFILLER_2_209 VGND VGND VPWR VPWR sky130_fd_sc_hd__fill_2
XFILLER_41_113 VGND VGND VPWR VPWR sky130_fd_sc_hd__fill_2
XFILLER_26_187 VGND VGND VPWR VPWR sky130_fd_sc_hd__fill_1
XFILLER_26_132 VGND VGND VPWR VPWR sky130_fd_sc_hd__decap_8
XFILLER_14_305 VGND VGND VPWR VPWR sky130_fd_sc_hd__decap_3
XFILLER_25_11 VGND VGND VPWR VPWR sky130_fd_sc_hd__fill_2
XFILLER_25_55 VGND VGND VPWR VPWR sky130_fd_sc_hd__fill_1
XFILLER_41_65 VGND VGND VPWR VPWR sky130_fd_sc_hd__decap_3
XFILLER_2_15 VPWR VGND VPWR VGND sky130_ef_sc_hd__decap_12
XFILLER_17_165 VGND VGND VPWR VPWR sky130_fd_sc_hd__decap_3
XFILLER_17_176 VGND VGND VPWR VPWR sky130_fd_sc_hd__fill_1
X_0882_ u_srf_ctrl.timer\[7\] _0567_ VGND VGND VPWR VPWR _0570_ sky130_fd_sc_hd__nand2_1
X_0951_ _0623_ _0624_ VGND VGND VPWR VPWR _0625_ sky130_fd_sc_hd__nand2_1
XFILLER_56_3 VPWR VGND VPWR VGND sky130_ef_sc_hd__decap_12
X_1503_ clknet_leaf_3_clk_10mhz _0029_ net58 VGND VGND VPWR VPWR u_srf_ctrl.timer\[7\]
+ sky130_fd_sc_hd__dfrtp_2
X_1296_ u_fifo.mem\[15\]\[1\] _0291_ _0305_ u_fifo.mem\[7\]\[1\] VGND VGND VPWR VPWR
+ _0327_ sky130_fd_sc_hd__a22o_1
X_1434_ net15 _0427_ u_srf_ctrl.echo_counter\[0\] VGND VGND VPWR VPWR _0258_ sky130_fd_sc_hd__mux2_1
X_1365_ u_fifo.mem\[6\]\[7\] _0297_ _0306_ u_fifo.mem\[14\]\[7\] VGND VGND VPWR VPWR
+ _0390_ sky130_fd_sc_hd__a22o_1
XFILLER_63_293 VPWR VGND VPWR VGND sky130_ef_sc_hd__decap_12
XFILLER_23_113 VPWR VGND VPWR VGND sky130_ef_sc_hd__decap_12
XFILLER_23_146 VGND VGND VPWR VPWR sky130_fd_sc_hd__fill_2
XFILLER_11_57 VPWR VGND VPWR VGND sky130_ef_sc_hd__decap_12
XTAP_TAPCELL_ROW_52_472 VGND VPWR sky130_fd_sc_hd__tapvpwrvgnd_1
XFILLER_6_323 VGND VGND VPWR VPWR sky130_fd_sc_hd__fill_1
XFILLER_6_356 VGND VGND VPWR VPWR sky130_fd_sc_hd__decap_8
X_1150_ net81 net38 _0738_ VGND VGND VPWR VPWR _0128_ sky130_fd_sc_hd__mux2_1
XTAP_TAPCELL_ROW_9_194 VGND VPWR sky130_fd_sc_hd__tapvpwrvgnd_1
X_1081_ net252 _0526_ VGND VGND VPWR VPWR _0085_ sky130_fd_sc_hd__xnor2_1
XFILLER_20_105 VGND VGND VPWR VPWR sky130_fd_sc_hd__decap_3
X_0865_ _0557_ _0558_ _0552_ VGND VGND VPWR VPWR _0023_ sky130_fd_sc_hd__and3b_1
X_0934_ net27 net28 VGND VGND VPWR VPWR _0608_ sky130_fd_sc_hd__nand2_1
XFILLER_13_190 VPWR VGND VPWR VGND sky130_ef_sc_hd__decap_12
X_1417_ net232 _0493_ VGND VGND VPWR VPWR _0252_ sky130_fd_sc_hd__and2_1
X_0796_ _0502_ _0510_ u_srf_ctrl.echo_sync_1 VGND VGND VPWR VPWR _0511_ sky130_fd_sc_hd__mux2_1
X_1348_ _0474_ u_fifo.mem\[2\]\[6\] _0303_ VGND VGND VPWR VPWR _0374_ sky130_fd_sc_hd__o21ba_1
X_1279_ net34 net26 net31 _0475_ VGND VGND VPWR VPWR _0311_ sky130_fd_sc_hd__and4b_4
Xclkbuf_leaf_21_clk_10mhz clknet_2_2__leaf_clk_10mhz VGND VGND VPWR VPWR clknet_leaf_21_clk_10mhz
+ sky130_fd_sc_hd__clkbuf_8
XFILLER_51_285 VGND VGND VPWR VPWR sky130_fd_sc_hd__fill_1
XFILLER_3_337 VPWR VGND VPWR VGND sky130_ef_sc_hd__decap_12
XTAP_TAPCELL_ROW_6_175 VGND VPWR sky130_fd_sc_hd__tapvpwrvgnd_1
XFILLER_63_85 VGND VGND VPWR VPWR sky130_fd_sc_hd__fill_2
XFILLER_63_41 VPWR VGND VPWR VGND sky130_ef_sc_hd__decap_12
XFILLER_47_86 VGND VGND VPWR VPWR sky130_fd_sc_hd__decap_3
XFILLER_19_249 VGND VGND VPWR VPWR sky130_fd_sc_hd__fill_1
XFILLER_6_153 VGND VGND VPWR VPWR sky130_fd_sc_hd__decap_6
XFILLER_6_186 VGND VGND VPWR VPWR sky130_fd_sc_hd__decap_4
XFILLER_6_197 VGND VGND VPWR VPWR sky130_fd_sc_hd__decap_3
X_1064_ _0710_ _0711_ VGND VGND VPWR VPWR _0712_ sky130_fd_sc_hd__nand2_4
X_1133_ _0732_ _0735_ VGND VGND VPWR VPWR _0736_ sky130_fd_sc_hd__nand2_4
X_1202_ net110 net46 _0281_ VGND VGND VPWR VPWR _0172_ sky130_fd_sc_hd__mux2_1
XTAP_TAPCELL_ROW_63_556 VGND VPWR sky130_fd_sc_hd__tapvpwrvgnd_1
XTAP_TAPCELL_ROW_63_545 VGND VPWR sky130_fd_sc_hd__tapvpwrvgnd_1
XFILLER_18_293 VGND VGND VPWR VPWR sky130_fd_sc_hd__decap_8
X_0779_ net4 _0493_ VGND VGND VPWR VPWR _0004_ sky130_fd_sc_hd__and2_1
X_0848_ _0491_ _0492_ VGND VGND VPWR VPWR _0544_ sky130_fd_sc_hd__nor2_1
X_0917_ u_srf_ctrl.timer\[17\] _0590_ u_srf_ctrl.timer\[18\] VGND VGND VPWR VPWR _0594_
+ sky130_fd_sc_hd__a21o_1
XTAP_TAPCELL_ROW_3_156 VGND VPWR sky130_fd_sc_hd__tapvpwrvgnd_1
XFILLER_24_230 VGND VGND VPWR VPWR sky130_fd_sc_hd__fill_2
Xhold7 u_fifo.mem\[0\]\[7\] VGND VGND VPWR VPWR net75 sky130_fd_sc_hd__dlygate4sd3_1
XFILLER_47_366 VGND VGND VPWR VPWR sky130_fd_sc_hd__decap_8
XFILLER_47_311 VGND VGND VPWR VPWR sky130_fd_sc_hd__decap_6
XTAP_TAPCELL_ROW_60_526 VGND VPWR sky130_fd_sc_hd__tapvpwrvgnd_1
XFILLER_15_230 VGND VGND VPWR VPWR sky130_fd_sc_hd__fill_2
XTAP_TAPCELL_ROW_17_247 VGND VPWR sky130_fd_sc_hd__tapvpwrvgnd_1
X_1682_ clknet_leaf_12_clk_10mhz _0185_ VGND VGND VPWR VPWR u_fifo.mem\[12\]\[7\]
+ sky130_fd_sc_hd__dfxtp_1
X_1751_ clknet_leaf_5_clk_10mhz _0254_ net62 VGND VGND VPWR VPWR u_uart.clk_count\[11\]
+ sky130_fd_sc_hd__dfrtp_1
X_1116_ net49 net172 _0733_ VGND VGND VPWR VPWR _0099_ sky130_fd_sc_hd__mux2_1
XFILLER_0_81 VGND VGND VPWR VPWR sky130_fd_sc_hd__decap_3
XTAP_TAPCELL_ROW_0_137 VGND VPWR sky130_fd_sc_hd__tapvpwrvgnd_1
X_1047_ u_packet_assembler.timer\[13\] _0699_ net267 VGND VGND VPWR VPWR _0705_ sky130_fd_sc_hd__a21oi_1
XFILLER_9_90 VPWR VGND VPWR VGND sky130_ef_sc_hd__decap_12
XFILLER_21_277 VGND VGND VPWR VPWR sky130_fd_sc_hd__decap_3
XFILLER_56_174 VGND VGND VPWR VPWR sky130_fd_sc_hd__fill_1
XFILLER_56_141 VGND VGND VPWR VPWR sky130_fd_sc_hd__decap_6
XFILLER_0_137 VGND VGND VPWR VPWR sky130_fd_sc_hd__decap_3
XFILLER_44_21 VGND VGND VPWR VPWR sky130_fd_sc_hd__fill_1
XFILLER_12_211 VGND VGND VPWR VPWR sky130_fd_sc_hd__decap_3
XTAP_TAPCELL_ROW_14_228 VGND VPWR sky130_fd_sc_hd__tapvpwrvgnd_1
XFILLER_60_97 VGND VGND VPWR VPWR sky130_fd_sc_hd__decap_4
XFILLER_5_15 VPWR VGND VPWR VGND sky130_ef_sc_hd__decap_12
XTAP_TAPCELL_ROW_22_283 VGND VPWR sky130_fd_sc_hd__tapvpwrvgnd_1
XPHY_EDGE_ROW_13_Right_13 VGND VGND VPWR VPWR sky130_fd_sc_hd__decap_3
XPHY_EDGE_ROW_22_Right_22 VGND VGND VPWR VPWR sky130_fd_sc_hd__decap_3
X_1596_ clknet_leaf_10_clk_10mhz _0099_ VGND VGND VPWR VPWR u_fifo.mem\[11\]\[1\]
+ sky130_fd_sc_hd__dfxtp_1
X_1665_ clknet_leaf_16_clk_10mhz _0168_ VGND VGND VPWR VPWR u_fifo.mem\[4\]\[6\] sky130_fd_sc_hd__dfxtp_1
XFILLER_7_281 VGND VGND VPWR VPWR sky130_fd_sc_hd__fill_1
XFILLER_7_292 VGND VGND VPWR VPWR sky130_fd_sc_hd__fill_1
Xhold204 u_srf_ctrl.echo_counter\[12\] VGND VGND VPWR VPWR net272 sky130_fd_sc_hd__dlygate4sd3_1
X_1734_ clknet_leaf_26_clk_10mhz _0237_ net53 VGND VGND VPWR VPWR distance_out\[1\]
+ sky130_fd_sc_hd__dfrtp_1
XFILLER_38_141 VGND VGND VPWR VPWR sky130_fd_sc_hd__decap_6
XPHY_EDGE_ROW_31_Right_31 VGND VGND VPWR VPWR sky130_fd_sc_hd__decap_3
XFILLER_26_347 VPWR VGND VPWR VGND sky130_ef_sc_hd__decap_12
XPHY_EDGE_ROW_40_Right_40 VGND VGND VPWR VPWR sky130_fd_sc_hd__decap_3
XFILLER_30_34 VGND VGND VPWR VPWR sky130_fd_sc_hd__decap_4
XTAP_TAPCELL_ROW_11_209 VGND VPWR sky130_fd_sc_hd__tapvpwrvgnd_1
XFILLER_55_42 VPWR VGND VPWR VGND sky130_ef_sc_hd__decap_12
XFILLER_44_122 VGND VGND VPWR VPWR sky130_fd_sc_hd__decap_4
XFILLER_39_87 VGND VGND VPWR VPWR sky130_fd_sc_hd__decap_4
XFILLER_29_196 VGND VGND VPWR VPWR sky130_fd_sc_hd__fill_1
XFILLER_32_306 VGND VGND VPWR VPWR sky130_fd_sc_hd__fill_2
XFILLER_4_251 VGND VGND VPWR VPWR sky130_fd_sc_hd__fill_1
X_1450_ net15 _0436_ _0438_ _0427_ u_srf_ctrl.echo_counter\[5\] VGND VGND VPWR VPWR
+ _0263_ sky130_fd_sc_hd__a32o_1
X_1381_ _0469_ net233 VGND VGND VPWR VPWR _0396_ sky130_fd_sc_hd__nand2_1
XFILLER_50_136 VGND VGND VPWR VPWR sky130_fd_sc_hd__decap_4
XFILLER_35_166 VGND VGND VPWR VPWR sky130_fd_sc_hd__fill_2
XFILLER_35_122 VGND VGND VPWR VPWR sky130_fd_sc_hd__decap_6
XFILLER_31_361 VPWR VGND VPWR VGND sky130_ef_sc_hd__decap_12
X_1717_ clknet_leaf_8_clk_10mhz _0220_ VGND VGND VPWR VPWR fifo_dout\[0\] sky130_fd_sc_hd__dfxtp_1
X_1648_ clknet_leaf_10_clk_10mhz _0151_ VGND VGND VPWR VPWR u_fifo.mem\[6\]\[5\] sky130_fd_sc_hd__dfxtp_1
X_1579_ clknet_leaf_1_clk_10mhz _0002_ net55 VGND VGND VPWR VPWR u_srf_ctrl.state\[2\]
+ sky130_fd_sc_hd__dfrtp_2
XFILLER_41_169 VGND VGND VPWR VPWR sky130_fd_sc_hd__decap_6
XFILLER_41_55 VGND VGND VPWR VPWR sky130_fd_sc_hd__fill_1
XFILLER_49_225 VGND VGND VPWR VPWR sky130_fd_sc_hd__decap_8
XFILLER_2_27 VGND VGND VPWR VPWR sky130_fd_sc_hd__fill_1
XTAP_TAPCELL_ROW_55_492 VGND VPWR sky130_fd_sc_hd__tapvpwrvgnd_1
XFILLER_17_111 VGND VGND VPWR VPWR sky130_fd_sc_hd__fill_1
X_0881_ net9 _0568_ _0569_ net19 net270 VGND VGND VPWR VPWR _0028_ sky130_fd_sc_hd__a32o_1
XFILLER_9_321 VPWR VGND VPWR VGND sky130_ef_sc_hd__decap_12
XFILLER_13_361 VPWR VGND VPWR VGND sky130_ef_sc_hd__decap_12
X_0950_ _0611_ _0616_ _0615_ VGND VGND VPWR VPWR _0624_ sky130_fd_sc_hd__o21ai_1
XFILLER_20_309 VPWR VGND VPWR VGND sky130_ef_sc_hd__decap_12
XFILLER_49_3 VPWR VGND VPWR VGND sky130_ef_sc_hd__decap_12
X_1502_ clknet_leaf_3_clk_10mhz _0028_ net58 VGND VGND VPWR VPWR u_srf_ctrl.timer\[6\]
+ sky130_fd_sc_hd__dfrtp_1
X_1433_ _0550_ _0426_ VGND VGND VPWR VPWR _0427_ sky130_fd_sc_hd__nor2_2
X_1364_ u_fifo.mem\[12\]\[7\] _0298_ _0312_ u_fifo.mem\[13\]\[7\] VGND VGND VPWR VPWR
+ _0389_ sky130_fd_sc_hd__a22o_1
XFILLER_48_291 VGND VGND VPWR VPWR sky130_fd_sc_hd__fill_1
X_1295_ u_fifo.mem\[12\]\[1\] _0298_ _0310_ u_fifo.mem\[11\]\[1\] _0325_ VGND VGND
+ VPWR VPWR _0326_ sky130_fd_sc_hd__a221o_1
XPHY_EDGE_ROW_43_Left_107 VGND VGND VPWR VPWR sky130_fd_sc_hd__decap_3
XFILLER_23_125 VPWR VGND VPWR VGND sky130_ef_sc_hd__decap_12
XPHY_EDGE_ROW_52_Left_116 VGND VGND VPWR VPWR sky130_fd_sc_hd__decap_3
XFILLER_11_69 VGND VGND VPWR VPWR sky130_fd_sc_hd__decap_8
XFILLER_61_209 VGND VGND VPWR VPWR sky130_fd_sc_hd__decap_4
XPHY_EDGE_ROW_61_Left_125 VGND VGND VPWR VPWR sky130_fd_sc_hd__decap_3
XFILLER_54_261 VGND VGND VPWR VPWR sky130_fd_sc_hd__decap_8
XFILLER_14_136 VGND VGND VPWR VPWR sky130_fd_sc_hd__decap_4
XTAP_TAPCELL_ROW_52_473 VGND VPWR sky130_fd_sc_hd__tapvpwrvgnd_1
X_1080_ net228 net204 net14 VGND VGND VPWR VPWR _0084_ sky130_fd_sc_hd__mux2_1
XTAP_TAPCELL_ROW_9_195 VGND VPWR sky130_fd_sc_hd__tapvpwrvgnd_1
XFILLER_20_139 VGND VGND VPWR VPWR sky130_fd_sc_hd__fill_1
X_0795_ _0506_ _0507_ _0509_ VGND VGND VPWR VPWR _0510_ sky130_fd_sc_hd__a21bo_1
X_0864_ u_srf_ctrl.timer\[0\] _0555_ u_srf_ctrl.timer\[1\] VGND VGND VPWR VPWR _0558_
+ sky130_fd_sc_hd__a21o_1
X_0933_ _0605_ _0606_ VGND VGND VPWR VPWR _0607_ sky130_fd_sc_hd__or2_1
X_1347_ _0373_ net162 _0296_ VGND VGND VPWR VPWR _0225_ sky130_fd_sc_hd__mux2_1
X_1416_ net227 _0493_ VGND VGND VPWR VPWR _0251_ sky130_fd_sc_hd__and2_1
XFILLER_51_220 VGND VGND VPWR VPWR sky130_fd_sc_hd__decap_4
X_1278_ net31 u_fifo.rd_ptr\[3\] net34 u_fifo.rd_ptr\[1\] VGND VGND VPWR VPWR _0310_
+ sky130_fd_sc_hd__and4b_4
Xclkbuf_leaf_25_clk_10mhz clknet_2_0__leaf_clk_10mhz VGND VGND VPWR VPWR clknet_leaf_25_clk_10mhz
+ sky130_fd_sc_hd__clkbuf_8
XPHY_EDGE_ROW_5_Left_69 VGND VGND VPWR VPWR sky130_fd_sc_hd__decap_3
XFILLER_3_349 VPWR VGND VPWR VGND sky130_ef_sc_hd__decap_12
XTAP_TAPCELL_ROW_57_510 VGND VPWR sky130_fd_sc_hd__tapvpwrvgnd_1
XFILLER_47_98 VGND VGND VPWR VPWR sky130_fd_sc_hd__fill_1
XFILLER_47_54 VGND VGND VPWR VPWR sky130_fd_sc_hd__fill_2
XTAP_TAPCELL_ROW_6_176 VGND VPWR sky130_fd_sc_hd__tapvpwrvgnd_1
XFILLER_63_53 VGND VGND VPWR VPWR sky130_fd_sc_hd__decap_3
XFILLER_42_253 VGND VGND VPWR VPWR sky130_fd_sc_hd__fill_1
XFILLER_8_15 VPWR VGND VPWR VGND sky130_ef_sc_hd__decap_12
X_1201_ net133 net48 _0281_ VGND VGND VPWR VPWR _0171_ sky130_fd_sc_hd__mux2_1
XTAP_TAPCELL_ROW_63_546 VGND VPWR sky130_fd_sc_hd__tapvpwrvgnd_1
X_1063_ u_fifo.wr_ptr\[2\] u_fifo.wr_ptr\[3\] net60 VGND VGND VPWR VPWR _0711_ sky130_fd_sc_hd__and3_2
X_1132_ net29 _0709_ u_fifo.wr_ptr\[0\] VGND VGND VPWR VPWR _0735_ sky130_fd_sc_hd__and3b_2
X_0916_ net9 _0592_ _0593_ net19 u_srf_ctrl.timer\[17\] VGND VGND VPWR VPWR _0039_
+ sky130_fd_sc_hd__a32o_1
X_0778_ u_uart.state\[1\] u_uart.state\[0\] VGND VGND VPWR VPWR _0494_ sky130_fd_sc_hd__or2_1
X_0847_ net151 _0542_ VGND VGND VPWR VPWR _0011_ sky130_fd_sc_hd__xor2_1
XTAP_TAPCELL_ROW_3_157 VGND VPWR sky130_fd_sc_hd__tapvpwrvgnd_1
XFILLER_17_57 VGND VGND VPWR VPWR sky130_fd_sc_hd__decap_8
XFILLER_24_286 VGND VGND VPWR VPWR sky130_fd_sc_hd__fill_1
XFILLER_3_113 VPWR VGND VPWR VGND sky130_ef_sc_hd__decap_12
Xhold8 u_fifo.mem\[1\]\[4\] VGND VGND VPWR VPWR net76 sky130_fd_sc_hd__dlygate4sd3_1
XTAP_TAPCELL_ROW_60_527 VGND VPWR sky130_fd_sc_hd__tapvpwrvgnd_1
X_1750_ clknet_leaf_4_clk_10mhz _0253_ net59 VGND VGND VPWR VPWR u_uart.clk_count\[10\]
+ sky130_fd_sc_hd__dfrtp_1
XFILLER_30_234 VGND VGND VPWR VPWR sky130_fd_sc_hd__fill_1
XTAP_TAPCELL_ROW_17_248 VGND VPWR sky130_fd_sc_hd__tapvpwrvgnd_1
X_1681_ clknet_leaf_10_clk_10mhz _0184_ VGND VGND VPWR VPWR u_fifo.mem\[12\]\[6\]
+ sky130_fd_sc_hd__dfxtp_1
XFILLER_2_190 VGND VGND VPWR VPWR sky130_fd_sc_hd__decap_6
XFILLER_53_337 VPWR VGND VPWR VGND sky130_ef_sc_hd__decap_12
X_1115_ net51 net184 _0733_ VGND VGND VPWR VPWR _0098_ sky130_fd_sc_hd__mux2_1
XTAP_TAPCELL_ROW_0_138 VGND VPWR sky130_fd_sc_hd__tapvpwrvgnd_1
X_1046_ _0703_ net13 VGND VGND VPWR VPWR _0704_ sky130_fd_sc_hd__and2b_1
XFILLER_29_345 VPWR VGND VPWR VGND sky130_ef_sc_hd__decap_12
XTAP_TAPCELL_ROW_14_229 VGND VPWR sky130_fd_sc_hd__tapvpwrvgnd_1
XFILLER_5_27 VPWR VGND VPWR VGND sky130_ef_sc_hd__decap_12
XPHY_EDGE_ROW_8_Left_72 VGND VGND VPWR VPWR sky130_fd_sc_hd__decap_3
XFILLER_62_134 VGND VGND VPWR VPWR sky130_fd_sc_hd__decap_6
XFILLER_35_304 VGND VGND VPWR VPWR sky130_fd_sc_hd__decap_6
X_1733_ clknet_leaf_2_clk_10mhz _0236_ net56 VGND VGND VPWR VPWR distance_out\[0\]
+ sky130_fd_sc_hd__dfrtp_1
Xhold205 u_uart.clk_count\[2\] VGND VGND VPWR VPWR net273 sky130_fd_sc_hd__dlygate4sd3_1
X_1664_ clknet_leaf_17_clk_10mhz _0167_ VGND VGND VPWR VPWR u_fifo.mem\[4\]\[5\] sky130_fd_sc_hd__dfxtp_1
X_1595_ clknet_leaf_25_clk_10mhz _0098_ VGND VGND VPWR VPWR u_fifo.mem\[11\]\[0\]
+ sky130_fd_sc_hd__dfxtp_1
XFILLER_38_197 VGND VGND VPWR VPWR sky130_fd_sc_hd__decap_8
XFILLER_41_329 VGND VGND VPWR VPWR sky130_fd_sc_hd__decap_6
XFILLER_26_359 VGND VGND VPWR VPWR sky130_fd_sc_hd__decap_4
X_1029_ u_packet_assembler.timer\[9\] _0689_ net13 VGND VGND VPWR VPWR _0692_ sky130_fd_sc_hd__o21ai_1
XFILLER_5_219 VGND VGND VPWR VPWR sky130_fd_sc_hd__fill_1
XFILLER_39_55 VGND VGND VPWR VPWR sky130_fd_sc_hd__fill_1
XFILLER_55_65 VGND VGND VPWR VPWR sky130_fd_sc_hd__decap_6
XFILLER_55_54 VGND VGND VPWR VPWR sky130_fd_sc_hd__fill_2
XFILLER_44_134 VGND VGND VPWR VPWR sky130_fd_sc_hd__decap_6
XPHY_EDGE_ROW_34_Left_98 VGND VGND VPWR VPWR sky130_fd_sc_hd__decap_3
XFILLER_32_329 VPWR VGND VPWR VGND sky130_ef_sc_hd__decap_12
XTAP_TAPCELL_ROW_27_310 VGND VPWR sky130_fd_sc_hd__tapvpwrvgnd_1
XFILLER_17_337 VPWR VGND VPWR VGND sky130_ef_sc_hd__decap_12
X_1380_ u_srf_ctrl.state\[3\] _0654_ _0395_ VGND VGND VPWR VPWR _0236_ sky130_fd_sc_hd__a21oi_1
XFILLER_35_134 VPWR VGND VPWR VGND sky130_ef_sc_hd__decap_12
X_1716_ clknet_leaf_2_clk_10mhz _0219_ net60 VGND VGND VPWR VPWR u_fifo.wr_ptr\[4\]
+ sky130_fd_sc_hd__dfrtp_1
XFILLER_31_373 VGND VGND VPWR VPWR sky130_fd_sc_hd__decap_4
X_1578_ clknet_leaf_1_clk_10mhz _0001_ net54 VGND VGND VPWR VPWR u_srf_ctrl.state\[1\]
+ sky130_fd_sc_hd__dfrtp_4
X_1647_ clknet_leaf_18_clk_10mhz _0150_ VGND VGND VPWR VPWR u_fifo.mem\[6\]\[4\] sky130_fd_sc_hd__dfxtp_1
XFILLER_25_57 VGND VGND VPWR VPWR sky130_fd_sc_hd__decap_6
XFILLER_9_3 VPWR VGND VPWR VGND sky130_ef_sc_hd__decap_12
XFILLER_49_204 VGND VGND VPWR VPWR sky130_fd_sc_hd__fill_2
XTAP_TAPCELL_ROW_55_493 VGND VPWR sky130_fd_sc_hd__tapvpwrvgnd_1
XFILLER_32_104 VPWR VGND VPWR VGND sky130_ef_sc_hd__decap_12
XFILLER_40_192 VGND VGND VPWR VPWR sky130_fd_sc_hd__decap_4
X_0880_ u_srf_ctrl.timer\[5\] u_srf_ctrl.timer\[4\] _0561_ u_srf_ctrl.timer\[6\] VGND
+ VGND VPWR VPWR _0569_ sky130_fd_sc_hd__a31o_1
XFILLER_9_333 VGND VGND VPWR VPWR sky130_fd_sc_hd__decap_3
XFILLER_13_373 VGND VGND VPWR VPWR sky130_fd_sc_hd__decap_4
X_1363_ u_fifo.mem\[8\]\[7\] _0300_ _0385_ _0386_ _0387_ VGND VGND VPWR VPWR _0388_
+ sky130_fd_sc_hd__a2111o_1
X_1501_ clknet_leaf_2_clk_10mhz _0027_ net60 VGND VGND VPWR VPWR u_srf_ctrl.timer\[5\]
+ sky130_fd_sc_hd__dfrtp_2
X_1432_ u_srf_ctrl.state\[2\] _0509_ _0513_ _0515_ _0425_ VGND VGND VPWR VPWR _0426_
+ sky130_fd_sc_hd__a41oi_2
XFILLER_63_251 VGND VGND VPWR VPWR sky130_fd_sc_hd__fill_1
XFILLER_55_207 VGND VGND VPWR VPWR sky130_fd_sc_hd__fill_1
X_1294_ u_fifo.mem\[10\]\[1\] _0307_ _0312_ u_fifo.mem\[13\]\[1\] VGND VGND VPWR VPWR
+ _0325_ sky130_fd_sc_hd__a22o_1
XFILLER_23_137 VGND VGND VPWR VPWR sky130_fd_sc_hd__decap_4
XFILLER_46_229 VGND VGND VPWR VPWR sky130_fd_sc_hd__decap_8
XFILLER_36_45 VGND VGND VPWR VPWR sky130_fd_sc_hd__fill_2
XFILLER_14_159 VGND VGND VPWR VPWR sky130_fd_sc_hd__fill_1
XTAP_TAPCELL_ROW_52_474 VGND VPWR sky130_fd_sc_hd__tapvpwrvgnd_1
XFILLER_10_321 VGND VGND VPWR VPWR sky130_fd_sc_hd__fill_1
XFILLER_10_365 VPWR VGND VPWR VGND sky130_ef_sc_hd__decap_12
XTAP_TAPCELL_ROW_9_196 VGND VPWR sky130_fd_sc_hd__tapvpwrvgnd_1
X_0932_ _0603_ _0604_ VGND VGND VPWR VPWR _0606_ sky130_fd_sc_hd__and2_1
XFILLER_61_3 VPWR VGND VPWR VGND sky130_ef_sc_hd__decap_12
X_0794_ u_srf_ctrl.timer\[17\] u_srf_ctrl.timer\[16\] _0508_ VGND VGND VPWR VPWR _0509_
+ sky130_fd_sc_hd__nor3_1
X_0863_ u_srf_ctrl.timer\[1\] u_srf_ctrl.timer\[0\] _0555_ VGND VGND VPWR VPWR _0557_
+ sky130_fd_sc_hd__and3_1
XFILLER_9_185 VGND VGND VPWR VPWR sky130_fd_sc_hd__fill_1
XPHY_EDGE_ROW_21_Left_85 VGND VGND VPWR VPWR sky130_fd_sc_hd__decap_3
X_1346_ u_fifo.mem\[0\]\[5\] _0322_ _0366_ _0372_ VGND VGND VPWR VPWR _0373_ sky130_fd_sc_hd__o22a_1
X_1415_ net218 _0493_ VGND VGND VPWR VPWR _0250_ sky130_fd_sc_hd__and2_1
X_1277_ _0475_ _0301_ VGND VGND VPWR VPWR _0309_ sky130_fd_sc_hd__nor2_4
XFILLER_11_129 VGND VGND VPWR VPWR sky130_fd_sc_hd__decap_6
XFILLER_27_262 VGND VGND VPWR VPWR sky130_fd_sc_hd__fill_1
XTAP_TAPCELL_ROW_6_177 VGND VPWR sky130_fd_sc_hd__tapvpwrvgnd_1
XFILLER_42_287 VGND VGND VPWR VPWR sky130_fd_sc_hd__decap_3
XTAP_TAPCELL_ROW_40_400 VGND VPWR sky130_fd_sc_hd__tapvpwrvgnd_1
XFILLER_8_27 VGND VGND VPWR VPWR sky130_fd_sc_hd__fill_1
X_1200_ net122 net50 _0281_ VGND VGND VPWR VPWR _0170_ sky130_fd_sc_hd__mux2_1
XTAP_TAPCELL_ROW_63_547 VGND VPWR sky130_fd_sc_hd__tapvpwrvgnd_1
X_1131_ net95 net36 _0734_ VGND VGND VPWR VPWR _0113_ sky130_fd_sc_hd__mux2_1
XFILLER_33_221 VGND VGND VPWR VPWR sky130_fd_sc_hd__decap_3
X_1062_ net30 net29 _0709_ VGND VGND VPWR VPWR _0710_ sky130_fd_sc_hd__and3_2
XFILLER_18_240 VGND VGND VPWR VPWR sky130_fd_sc_hd__decap_6
X_0915_ u_srf_ctrl.timer\[17\] _0590_ VGND VGND VPWR VPWR _0593_ sky130_fd_sc_hd__or2_1
X_0777_ u_uart.state\[1\] u_uart.state\[0\] VGND VGND VPWR VPWR _0493_ sky130_fd_sc_hd__nor2_2
XFILLER_0_309 VPWR VGND VPWR VGND sky130_ef_sc_hd__decap_12
X_0846_ _0542_ _0543_ VGND VGND VPWR VPWR _0010_ sky130_fd_sc_hd__nor2_1
X_1329_ u_fifo.mem\[6\]\[4\] _0297_ _0310_ u_fifo.mem\[11\]\[4\] VGND VGND VPWR VPWR
+ _0357_ sky130_fd_sc_hd__a22o_1
XTAP_TAPCELL_ROW_3_158 VGND VPWR sky130_fd_sc_hd__tapvpwrvgnd_1
XFILLER_33_57 VPWR VGND VPWR VGND sky130_ef_sc_hd__decap_12
XFILLER_3_125 VPWR VGND VPWR VGND sky130_ef_sc_hd__decap_12
Xhold9 u_fifo.mem\[0\]\[1\] VGND VGND VPWR VPWR net77 sky130_fd_sc_hd__dlygate4sd3_1
XFILLER_3_147 VPWR VGND VPWR VGND sky130_ef_sc_hd__decap_12
XFILLER_59_195 VGND VGND VPWR VPWR sky130_fd_sc_hd__fill_1
XFILLER_15_210 VGND VGND VPWR VPWR sky130_fd_sc_hd__fill_2
XFILLER_15_243 VPWR VGND VPWR VGND sky130_ef_sc_hd__decap_12
XTAP_TAPCELL_ROW_17_249 VGND VPWR sky130_fd_sc_hd__tapvpwrvgnd_1
XTAP_TAPCELL_ROW_60_528 VGND VPWR sky130_fd_sc_hd__tapvpwrvgnd_1
X_1680_ clknet_leaf_8_clk_10mhz _0183_ VGND VGND VPWR VPWR u_fifo.mem\[12\]\[5\] sky130_fd_sc_hd__dfxtp_1
XFILLER_38_324 VGND VGND VPWR VPWR sky130_fd_sc_hd__decap_8
X_1114_ _0710_ _0732_ VGND VGND VPWR VPWR _0733_ sky130_fd_sc_hd__nand2_4
XFILLER_24_3 VPWR VGND VPWR VGND sky130_ef_sc_hd__decap_12
XFILLER_53_349 VPWR VGND VPWR VGND sky130_ef_sc_hd__decap_12
XTAP_TAPCELL_ROW_0_139 VGND VPWR sky130_fd_sc_hd__tapvpwrvgnd_1
XTAP_TAPCELL_ROW_0_128 VGND VPWR sky130_fd_sc_hd__tapvpwrvgnd_1
X_1045_ u_packet_assembler.timer\[14\] u_packet_assembler.timer\[13\] _0699_ VGND
+ VGND VPWR VPWR _0703_ sky130_fd_sc_hd__and3_1
X_0829_ net247 _0532_ VGND VGND VPWR VPWR _0018_ sky130_fd_sc_hd__xor2_1
XFILLER_29_357 VPWR VGND VPWR VGND sky130_ef_sc_hd__decap_12
XFILLER_29_335 VGND VGND VPWR VPWR sky130_fd_sc_hd__fill_1
XFILLER_28_46 VGND VGND VPWR VPWR sky130_fd_sc_hd__decap_6
XFILLER_12_279 VGND VGND VPWR VPWR sky130_fd_sc_hd__fill_1
XFILLER_5_39 VGND VGND VPWR VPWR sky130_fd_sc_hd__fill_2
XFILLER_47_165 VGND VGND VPWR VPWR sky130_fd_sc_hd__decap_3
X_1732_ clknet_leaf_12_clk_10mhz _0235_ VGND VGND VPWR VPWR u_fifo.mem\[13\]\[7\]
+ sky130_fd_sc_hd__dfxtp_1
X_1663_ clknet_leaf_10_clk_10mhz _0166_ VGND VGND VPWR VPWR u_fifo.mem\[4\]\[4\] sky130_fd_sc_hd__dfxtp_1
Xhold206 u_srf_ctrl.timer\[14\] VGND VGND VPWR VPWR net274 sky130_fd_sc_hd__dlygate4sd3_1
XFILLER_7_250 VGND VGND VPWR VPWR sky130_fd_sc_hd__decap_3
XPHY_EDGE_ROW_7_Right_7 VGND VGND VPWR VPWR sky130_fd_sc_hd__decap_3
X_1594_ clknet_leaf_25_clk_10mhz _0097_ net21 VGND VGND VPWR VPWR u_packet_assembler.state\[3\]
+ sky130_fd_sc_hd__dfrtp_2
XFILLER_53_113 VGND VGND VPWR VPWR sky130_fd_sc_hd__decap_6
XFILLER_38_176 VGND VGND VPWR VPWR sky130_fd_sc_hd__fill_2
XFILLER_38_154 VGND VGND VPWR VPWR sky130_fd_sc_hd__decap_8
XFILLER_26_305 VGND VGND VPWR VPWR sky130_fd_sc_hd__decap_3
XFILLER_41_319 VGND VGND VPWR VPWR sky130_fd_sc_hd__fill_2
X_1028_ u_packet_assembler.timer\[7\] u_packet_assembler.timer\[8\] u_packet_assembler.timer\[9\]
+ _0683_ VGND VGND VPWR VPWR _0691_ sky130_fd_sc_hd__and4_1
XFILLER_29_121 VGND VGND VPWR VPWR sky130_fd_sc_hd__decap_8
XFILLER_29_110 VGND VGND VPWR VPWR sky130_fd_sc_hd__fill_2
XTAP_TAPCELL_ROW_27_311 VGND VPWR sky130_fd_sc_hd__tapvpwrvgnd_1
XFILLER_17_349 VPWR VGND VPWR VGND sky130_ef_sc_hd__decap_12
XFILLER_25_360 VPWR VGND VPWR VGND sky130_ef_sc_hd__decap_12
XFILLER_40_352 VPWR VGND VPWR VGND sky130_ef_sc_hd__decap_12
XTAP_TAPCELL_ROW_10_200 VGND VPWR sky130_fd_sc_hd__tapvpwrvgnd_1
XFILLER_4_253 VPWR VGND VPWR VGND sky130_ef_sc_hd__decap_12
XFILLER_4_220 VGND VGND VPWR VPWR sky130_fd_sc_hd__fill_1
XFILLER_35_146 VPWR VGND VPWR VGND sky130_ef_sc_hd__decap_12
XFILLER_35_113 VGND VGND VPWR VPWR sky130_fd_sc_hd__fill_2
X_1715_ clknet_leaf_2_clk_10mhz _0218_ net60 VGND VGND VPWR VPWR u_fifo.wr_ptr\[3\]
+ sky130_fd_sc_hd__dfrtp_2
X_1646_ clknet_leaf_19_clk_10mhz _0149_ VGND VGND VPWR VPWR u_fifo.mem\[6\]\[3\] sky130_fd_sc_hd__dfxtp_1
XFILLER_6_82 VGND VGND VPWR VPWR sky130_fd_sc_hd__fill_2
X_1577_ clknet_leaf_2_clk_10mhz _0000_ net54 VGND VGND VPWR VPWR u_srf_ctrl.state\[0\]
+ sky130_fd_sc_hd__dfstp_1
XFILLER_26_179 VGND VGND VPWR VPWR sky130_fd_sc_hd__decap_8
XFILLER_41_79 VGND VGND VPWR VPWR sky130_fd_sc_hd__fill_1
XFILLER_41_57 VGND VGND VPWR VPWR sky130_fd_sc_hd__decap_8
XFILLER_41_35 VPWR VGND VPWR VGND sky130_ef_sc_hd__decap_12
XFILLER_22_363 VGND VGND VPWR VPWR sky130_fd_sc_hd__fill_1
XFILLER_1_223 VGND VGND VPWR VPWR sky130_fd_sc_hd__fill_1
XFILLER_57_260 VGND VGND VPWR VPWR sky130_fd_sc_hd__decap_6
XFILLER_2_29 VPWR VGND VPWR VGND sky130_ef_sc_hd__decap_12
XFILLER_17_113 VGND VGND VPWR VPWR sky130_fd_sc_hd__decap_6
XTAP_TAPCELL_ROW_55_494 VGND VPWR sky130_fd_sc_hd__tapvpwrvgnd_1
XFILLER_32_116 VGND VGND VPWR VPWR sky130_fd_sc_hd__decap_3
XFILLER_15_80 VGND VGND VPWR VPWR sky130_fd_sc_hd__decap_6
X_1500_ clknet_leaf_1_clk_10mhz _0026_ net54 VGND VGND VPWR VPWR u_srf_ctrl.timer\[4\]
+ sky130_fd_sc_hd__dfrtp_1
X_1362_ _0474_ u_fifo.mem\[2\]\[7\] _0303_ VGND VGND VPWR VPWR _0387_ sky130_fd_sc_hd__o21ba_1
X_1293_ net26 u_fifo.mem\[2\]\[1\] VGND VGND VPWR VPWR _0324_ sky130_fd_sc_hd__nor2_1
X_1431_ u_srf_ctrl.echo_sync_1 u_srf_ctrl.state\[1\] VGND VGND VPWR VPWR _0425_ sky130_fd_sc_hd__nand2_1
X_1629_ clknet_leaf_19_clk_10mhz _0132_ VGND VGND VPWR VPWR u_fifo.mem\[14\]\[2\]
+ sky130_fd_sc_hd__dfxtp_1
XTAP_TAPCELL_ROW_52_475 VGND VPWR sky130_fd_sc_hd__tapvpwrvgnd_1
XFILLER_52_34 VGND VGND VPWR VPWR sky130_fd_sc_hd__fill_2
XFILLER_52_23 VGND VGND VPWR VPWR sky130_fd_sc_hd__fill_2
XFILLER_36_68 VGND VGND VPWR VPWR sky130_fd_sc_hd__fill_1
XFILLER_14_127 VGND VGND VPWR VPWR sky130_fd_sc_hd__decap_6
XTAP_TAPCELL_ROW_9_197 VGND VPWR sky130_fd_sc_hd__tapvpwrvgnd_1
XFILLER_45_241 VGND VGND VPWR VPWR sky130_fd_sc_hd__decap_3
X_0862_ net259 _0555_ _0556_ VGND VGND VPWR VPWR _0022_ sky130_fd_sc_hd__a21oi_1
X_0931_ _0603_ _0604_ VGND VGND VPWR VPWR _0605_ sky130_fd_sc_hd__nor2_1
XFILLER_13_160 VGND VGND VPWR VPWR sky130_fd_sc_hd__decap_8
XFILLER_54_3 VPWR VGND VPWR VGND sky130_ef_sc_hd__decap_12
X_0793_ u_srf_ctrl.timer\[20\] u_srf_ctrl.timer\[19\] u_srf_ctrl.timer\[18\] u_srf_ctrl.timer\[15\]
+ VGND VGND VPWR VPWR _0508_ sky130_fd_sc_hd__or4_1
X_1414_ _0471_ _0415_ _0406_ VGND VGND VPWR VPWR _0249_ sky130_fd_sc_hd__a21oi_1
X_1276_ net34 net26 net31 _0475_ VGND VGND VPWR VPWR _0308_ sky130_fd_sc_hd__and4_4
X_1345_ _0368_ _0370_ _0371_ VGND VGND VPWR VPWR _0372_ sky130_fd_sc_hd__or3_1
XFILLER_22_37 VPWR VGND VPWR VGND sky130_ef_sc_hd__decap_12
XFILLER_22_59 VGND VGND VPWR VPWR sky130_fd_sc_hd__decap_8
XFILLER_59_311 VPWR VGND VPWR VGND sky130_ef_sc_hd__decap_12
XFILLER_27_285 VGND VGND VPWR VPWR sky130_fd_sc_hd__fill_1
XTAP_TAPCELL_ROW_6_178 VGND VPWR sky130_fd_sc_hd__tapvpwrvgnd_1
XFILLER_10_141 VGND VGND VPWR VPWR sky130_fd_sc_hd__fill_2
XFILLER_40_9 VGND VGND VPWR VPWR sky130_fd_sc_hd__fill_1
XFILLER_6_167 VGND VGND VPWR VPWR sky130_fd_sc_hd__decap_4
XFILLER_12_70 VGND VGND VPWR VPWR sky130_fd_sc_hd__fill_1
X_1130_ net101 net39 _0734_ VGND VGND VPWR VPWR _0112_ sky130_fd_sc_hd__mux2_1
XFILLER_19_6 VPWR VGND VPWR VGND sky130_ef_sc_hd__decap_12
XTAP_TAPCELL_ROW_63_548 VGND VPWR sky130_fd_sc_hd__tapvpwrvgnd_1
X_1061_ _0491_ _0492_ fifo_wr_en VGND VGND VPWR VPWR _0709_ sky130_fd_sc_hd__o21a_2
XFILLER_33_244 VPWR VGND VPWR VGND sky130_ef_sc_hd__decap_12
X_0914_ u_srf_ctrl.timer\[17\] _0590_ VGND VGND VPWR VPWR _0592_ sky130_fd_sc_hd__nand2_1
X_0845_ net280 _0540_ net243 VGND VGND VPWR VPWR _0543_ sky130_fd_sc_hd__a21oi_1
X_0776_ _0491_ _0492_ VGND VGND VPWR VPWR net4 sky130_fd_sc_hd__nand2b_1
X_1328_ u_fifo.mem\[15\]\[4\] _0291_ _0305_ u_fifo.mem\[7\]\[4\] _0355_ VGND VGND
+ VPWR VPWR _0356_ sky130_fd_sc_hd__a221o_1
X_1259_ net269 _0710_ VGND VGND VPWR VPWR _0217_ sky130_fd_sc_hd__xor2_1
XTAP_TAPCELL_ROW_3_159 VGND VPWR sky130_fd_sc_hd__tapvpwrvgnd_1
XPHY_EDGE_ROW_49_Left_113 VGND VGND VPWR VPWR sky130_fd_sc_hd__decap_3
XFILLER_33_69 VGND VGND VPWR VPWR sky130_fd_sc_hd__decap_3
XFILLER_3_159 VGND VGND VPWR VPWR sky130_fd_sc_hd__fill_2
XFILLER_3_137 VGND VGND VPWR VPWR sky130_fd_sc_hd__fill_2
XPHY_EDGE_ROW_58_Left_122 VGND VGND VPWR VPWR sky130_fd_sc_hd__decap_3
XFILLER_62_306 VGND VGND VPWR VPWR sky130_fd_sc_hd__fill_2
XTAP_TAPCELL_ROW_60_529 VGND VPWR sky130_fd_sc_hd__tapvpwrvgnd_1
XFILLER_15_222 VGND VGND VPWR VPWR sky130_fd_sc_hd__fill_2
XFILLER_15_255 VPWR VGND VPWR VGND sky130_ef_sc_hd__decap_12
Xclkbuf_leaf_11_clk_10mhz clknet_2_3__leaf_clk_10mhz VGND VGND VPWR VPWR clknet_leaf_11_clk_10mhz
+ sky130_fd_sc_hd__clkbuf_8
X_1113_ u_fifo.wr_ptr\[2\] u_fifo.wr_ptr\[3\] net60 VGND VGND VPWR VPWR _0732_ sky130_fd_sc_hd__and3b_2
XTAP_TAPCELL_ROW_0_129 VGND VPWR sky130_fd_sc_hd__tapvpwrvgnd_1
X_1044_ net13 _0701_ _0702_ net17 net277 VGND VGND VPWR VPWR _0058_ sky130_fd_sc_hd__a32o_1
XFILLER_61_361 VPWR VGND VPWR VGND sky130_ef_sc_hd__decap_12
X_0828_ _0532_ _0533_ VGND VGND VPWR VPWR _0017_ sky130_fd_sc_hd__and2b_1
X_0759_ u_packet_assembler.state\[0\] VGND VGND VPWR VPWR _0477_ sky130_fd_sc_hd__inv_2
XFILLER_52_350 VPWR VGND VPWR VGND sky130_ef_sc_hd__decap_12
XFILLER_29_369 VGND VGND VPWR VPWR sky130_fd_sc_hd__decap_8
XFILLER_47_188 VGND VGND VPWR VPWR sky130_fd_sc_hd__fill_1
XFILLER_47_111 VGND VGND VPWR VPWR sky130_fd_sc_hd__fill_1
XFILLER_43_361 VPWR VGND VPWR VGND sky130_ef_sc_hd__decap_12
XTAP_TAPCELL_ROW_13_220 VGND VPWR sky130_fd_sc_hd__tapvpwrvgnd_1
X_1662_ clknet_leaf_14_clk_10mhz _0165_ VGND VGND VPWR VPWR u_fifo.mem\[4\]\[3\] sky130_fd_sc_hd__dfxtp_1
X_1731_ clknet_leaf_11_clk_10mhz _0234_ VGND VGND VPWR VPWR u_fifo.mem\[13\]\[6\]
+ sky130_fd_sc_hd__dfxtp_1
Xhold207 u_srf_ctrl.timer\[7\] VGND VGND VPWR VPWR net275 sky130_fd_sc_hd__dlygate4sd3_1
XFILLER_7_240 VGND VGND VPWR VPWR sky130_fd_sc_hd__fill_1
X_1593_ clknet_leaf_26_clk_10mhz _0096_ net20 VGND VGND VPWR VPWR u_packet_assembler.state\[2\]
+ sky130_fd_sc_hd__dfrtp_1
XFILLER_38_122 VGND VGND VPWR VPWR sky130_fd_sc_hd__fill_1
XFILLER_34_350 VPWR VGND VPWR VGND sky130_ef_sc_hd__decap_12
X_1027_ net12 _0688_ _0690_ net18 net268 VGND VGND VPWR VPWR _0053_ sky130_fd_sc_hd__a32o_1
XFILLER_30_26 VGND VGND VPWR VPWR sky130_fd_sc_hd__fill_2
XFILLER_32_309 VGND VGND VPWR VPWR sky130_fd_sc_hd__decap_3
XTAP_TAPCELL_ROW_27_312 VGND VPWR sky130_fd_sc_hd__tapvpwrvgnd_1
XFILLER_25_372 VGND VGND VPWR VPWR sky130_fd_sc_hd__decap_4
XTAP_TAPCELL_ROW_10_201 VGND VPWR sky130_fd_sc_hd__tapvpwrvgnd_1
XFILLER_4_265 VPWR VGND VPWR VGND sky130_ef_sc_hd__decap_12
XFILLER_4_243 VGND VGND VPWR VPWR sky130_fd_sc_hd__decap_8
Xhold90 u_fifo.mem\[10\]\[0\] VGND VGND VPWR VPWR net158 sky130_fd_sc_hd__dlygate4sd3_1
XFILLER_35_169 VGND VGND VPWR VPWR sky130_fd_sc_hd__decap_4
XFILLER_35_158 VGND VGND VPWR VPWR sky130_fd_sc_hd__decap_8
XFILLER_16_361 VGND VGND VPWR VPWR sky130_fd_sc_hd__decap_3
X_1576_ clknet_leaf_7_clk_10mhz _0084_ net64 VGND VGND VPWR VPWR u_uart.tx_data_reg\[7\]
+ sky130_fd_sc_hd__dfrtp_1
X_1714_ clknet_leaf_2_clk_10mhz _0217_ net57 VGND VGND VPWR VPWR u_fifo.wr_ptr\[2\]
+ sky130_fd_sc_hd__dfrtp_2
X_1645_ clknet_leaf_19_clk_10mhz _0148_ VGND VGND VPWR VPWR u_fifo.mem\[6\]\[2\] sky130_fd_sc_hd__dfxtp_1
XFILLER_58_206 VGND VGND VPWR VPWR sky130_fd_sc_hd__decap_3
XFILLER_14_309 VGND VGND VPWR VPWR sky130_fd_sc_hd__decap_4
XFILLER_41_47 VGND VGND VPWR VPWR sky130_fd_sc_hd__decap_8
XFILLER_1_279 VGND VGND VPWR VPWR sky130_fd_sc_hd__fill_1
XTAP_TAPCELL_ROW_55_495 VGND VPWR sky130_fd_sc_hd__tapvpwrvgnd_1
XTAP_TAPCELL_ROW_30_329 VGND VPWR sky130_fd_sc_hd__tapvpwrvgnd_1
X_1430_ u_uart.bit_index\[2\] _0418_ _0419_ _0424_ VGND VGND VPWR VPWR _0257_ sky130_fd_sc_hd__o31a_1
X_1292_ _0323_ net170 _0296_ VGND VGND VPWR VPWR _0220_ sky130_fd_sc_hd__mux2_1
X_1361_ u_fifo.mem\[9\]\[7\] _0309_ _0310_ u_fifo.mem\[11\]\[7\] VGND VGND VPWR VPWR
+ _0386_ sky130_fd_sc_hd__a22o_1
XFILLER_63_253 VPWR VGND VPWR VGND sky130_ef_sc_hd__decap_12
XFILLER_31_150 VGND VGND VPWR VPWR sky130_fd_sc_hd__fill_2
X_1628_ clknet_leaf_18_clk_10mhz _0131_ VGND VGND VPWR VPWR u_fifo.mem\[14\]\[1\]
+ sky130_fd_sc_hd__dfxtp_1
X_1559_ clknet_leaf_20_clk_10mhz _0010_ net25 VGND VGND VPWR VPWR u_max30102_ctrl.clk_div\[14\]
+ sky130_fd_sc_hd__dfrtp_1
XFILLER_36_25 VGND VGND VPWR VPWR sky130_fd_sc_hd__decap_3
XTAP_TAPCELL_ROW_52_476 VGND VPWR sky130_fd_sc_hd__tapvpwrvgnd_1
XFILLER_22_161 VPWR VGND VPWR VGND sky130_ef_sc_hd__decap_12
XTAP_TAPCELL_ROW_9_198 VGND VPWR sky130_fd_sc_hd__tapvpwrvgnd_1
XFILLER_60_212 VGND VGND VPWR VPWR sky130_fd_sc_hd__decap_3
XFILLER_45_220 VGND VGND VPWR VPWR sky130_fd_sc_hd__decap_4
X_0792_ u_srf_ctrl.timer\[14\] u_srf_ctrl.timer\[13\] u_srf_ctrl.timer\[12\] VGND
+ VGND VPWR VPWR _0507_ sky130_fd_sc_hd__and3_1
X_0861_ u_srf_ctrl.timer\[0\] _0555_ _0552_ VGND VGND VPWR VPWR _0556_ sky130_fd_sc_hd__o21ai_1
X_0930_ u_srf_ctrl.echo_counter\[13\] u_srf_ctrl.echo_counter\[9\] VGND VGND VPWR
+ VPWR _0604_ sky130_fd_sc_hd__nand2_1
X_1413_ _0405_ _0415_ _0416_ VGND VGND VPWR VPWR _0248_ sky130_fd_sc_hd__and3_1
XFILLER_47_3 VPWR VGND VPWR VGND sky130_ef_sc_hd__decap_12
X_1275_ net26 _0299_ VGND VGND VPWR VPWR _0307_ sky130_fd_sc_hd__nor2_4
XFILLER_36_231 VGND VGND VPWR VPWR sky130_fd_sc_hd__decap_4
X_1344_ u_fifo.mem\[10\]\[5\] _0307_ _0313_ u_fifo.mem\[3\]\[5\] _0364_ VGND VGND
+ VPWR VPWR _0371_ sky130_fd_sc_hd__a221o_1
XFILLER_3_51 VGND VGND VPWR VPWR sky130_fd_sc_hd__decap_4
XFILLER_51_201 VGND VGND VPWR VPWR sky130_fd_sc_hd__decap_3
XFILLER_22_27 VGND VGND VPWR VPWR sky130_fd_sc_hd__fill_1
XFILLER_22_49 VGND VGND VPWR VPWR sky130_fd_sc_hd__decap_6
XFILLER_59_323 VPWR VGND VPWR VGND sky130_ef_sc_hd__decap_12
XFILLER_47_35 VGND VGND VPWR VPWR sky130_fd_sc_hd__decap_6
Xclkbuf_0_clk_10mhz clk_10mhz VGND VGND VPWR VPWR clknet_0_clk_10mhz sky130_fd_sc_hd__clkbuf_16
XTAP_TAPCELL_ROW_6_179 VGND VPWR sky130_fd_sc_hd__tapvpwrvgnd_1
XFILLER_47_57 VGND VGND VPWR VPWR sky130_fd_sc_hd__fill_1
XPHY_EDGE_ROW_29_Right_29 VGND VGND VPWR VPWR sky130_fd_sc_hd__decap_3
XPHY_EDGE_ROW_38_Right_38 VGND VGND VPWR VPWR sky130_fd_sc_hd__decap_3
XFILLER_10_175 VPWR VGND VPWR VGND sky130_ef_sc_hd__decap_12
XFILLER_2_363 VGND VGND VPWR VPWR sky130_fd_sc_hd__fill_1
XFILLER_10_197 VGND VGND VPWR VPWR sky130_fd_sc_hd__fill_1
XPHY_EDGE_ROW_47_Right_47 VGND VGND VPWR VPWR sky130_fd_sc_hd__decap_3
X_1060_ net212 net18 VGND VGND VPWR VPWR _0068_ sky130_fd_sc_hd__and2_1
XTAP_TAPCELL_ROW_63_549 VGND VPWR sky130_fd_sc_hd__tapvpwrvgnd_1
XPHY_EDGE_ROW_56_Right_56 VGND VGND VPWR VPWR sky130_fd_sc_hd__decap_3
XFILLER_33_289 VGND VGND VPWR VPWR sky130_fd_sc_hd__fill_1
XFILLER_33_256 VGND VGND VPWR VPWR sky130_fd_sc_hd__fill_1
X_0775_ u_fifo.rd_ptr\[4\] u_fifo.wr_ptr\[4\] VGND VGND VPWR VPWR _0492_ sky130_fd_sc_hd__xnor2_1
X_0913_ u_srf_ctrl.timer\[16\] net19 net9 _0591_ VGND VGND VPWR VPWR _0038_ sky130_fd_sc_hd__a22o_1
X_0844_ u_max30102_ctrl.clk_div\[13\] u_max30102_ctrl.clk_div\[14\] _0540_ VGND VGND
+ VPWR VPWR _0542_ sky130_fd_sc_hd__and3_1
X_1327_ u_fifo.mem\[10\]\[4\] _0307_ _0309_ u_fifo.mem\[9\]\[4\] VGND VGND VPWR VPWR
+ _0355_ sky130_fd_sc_hd__a22o_1
X_1189_ net60 _0737_ _0740_ VGND VGND VPWR VPWR _0279_ sky130_fd_sc_hd__and3_4
X_1258_ _0735_ _0293_ VGND VGND VPWR VPWR _0216_ sky130_fd_sc_hd__or2_1
Xclkbuf_2_0__f_clk_10mhz clknet_0_clk_10mhz VGND VGND VPWR VPWR clknet_2_0__leaf_clk_10mhz
+ sky130_fd_sc_hd__clkbuf_16
XFILLER_15_267 VPWR VGND VPWR VGND sky130_ef_sc_hd__decap_12
Xclkbuf_leaf_15_clk_10mhz clknet_2_3__leaf_clk_10mhz VGND VGND VPWR VPWR clknet_leaf_15_clk_10mhz
+ sky130_fd_sc_hd__clkbuf_8
XFILLER_38_304 VGND VGND VPWR VPWR sky130_fd_sc_hd__decap_4
XFILLER_38_359 VGND VGND VPWR VPWR sky130_fd_sc_hd__decap_4
XFILLER_0_41 VPWR VGND VPWR VGND sky130_ef_sc_hd__decap_12
XFILLER_0_85 VPWR VGND VPWR VGND sky130_ef_sc_hd__decap_12
X_1043_ u_packet_assembler.timer\[13\] _0699_ VGND VGND VPWR VPWR _0702_ sky130_fd_sc_hd__nand2_1
X_1112_ u_packet_assembler.state\[3\] _0730_ _0731_ _0715_ VGND VGND VPWR VPWR _0097_
+ sky130_fd_sc_hd__a22o_1
XFILLER_61_373 VGND VGND VPWR VPWR sky130_fd_sc_hd__decap_4
XTAP_TAPCELL_ROW_16_240 VGND VPWR sky130_fd_sc_hd__tapvpwrvgnd_1
X_0827_ u_max30102_ctrl.clk_div\[5\] u_max30102_ctrl.clk_div\[4\] _0527_ u_max30102_ctrl.clk_div\[6\]
+ VGND VGND VPWR VPWR _0533_ sky130_fd_sc_hd__a31o_1
X_0758_ u_srf_ctrl.state\[1\] VGND VGND VPWR VPWR _0476_ sky130_fd_sc_hd__inv_2
XFILLER_56_123 VGND VGND VPWR VPWR sky130_fd_sc_hd__fill_1
XFILLER_56_101 VGND VGND VPWR VPWR sky130_fd_sc_hd__fill_2
XFILLER_29_304 VGND VGND VPWR VPWR sky130_fd_sc_hd__decap_8
XFILLER_52_362 VGND VGND VPWR VPWR sky130_fd_sc_hd__fill_2
XFILLER_37_370 VGND VGND VPWR VPWR sky130_fd_sc_hd__decap_6
XFILLER_12_226 VGND VGND VPWR VPWR sky130_fd_sc_hd__decap_3
XFILLER_8_219 VPWR VGND VPWR VGND sky130_ef_sc_hd__decap_12
XFILLER_12_248 VGND VGND VPWR VPWR sky130_fd_sc_hd__decap_4
XFILLER_18_70 VPWR VGND VPWR VGND sky130_ef_sc_hd__decap_12
XFILLER_43_373 VGND VGND VPWR VPWR sky130_fd_sc_hd__decap_4
XTAP_TAPCELL_ROW_13_221 VGND VPWR sky130_fd_sc_hd__tapvpwrvgnd_1
X_1730_ clknet_leaf_12_clk_10mhz _0233_ VGND VGND VPWR VPWR u_fifo.mem\[13\]\[5\]
+ sky130_fd_sc_hd__dfxtp_1
X_1661_ clknet_leaf_15_clk_10mhz _0164_ VGND VGND VPWR VPWR u_fifo.mem\[4\]\[2\] sky130_fd_sc_hd__dfxtp_1
Xhold208 u_srf_ctrl.echo_counter\[14\] VGND VGND VPWR VPWR net276 sky130_fd_sc_hd__dlygate4sd3_1
XFILLER_11_292 VGND VGND VPWR VPWR sky130_fd_sc_hd__decap_3
X_1592_ clknet_leaf_26_clk_10mhz _0095_ net20 VGND VGND VPWR VPWR u_packet_assembler.state\[1\]
+ sky130_fd_sc_hd__dfrtp_2
XTAP_TAPCELL_ROW_36_368 VGND VPWR sky130_fd_sc_hd__tapvpwrvgnd_1
XFILLER_34_362 VGND VGND VPWR VPWR sky130_fd_sc_hd__fill_2
X_1026_ _0689_ VGND VGND VPWR VPWR _0690_ sky130_fd_sc_hd__inv_2
XFILLER_30_49 VPWR VGND VPWR VGND sky130_ef_sc_hd__decap_12
XFILLER_55_57 VGND VGND VPWR VPWR sky130_fd_sc_hd__decap_4
XFILLER_44_126 VGND VGND VPWR VPWR sky130_fd_sc_hd__fill_1
XFILLER_29_167 VGND VGND VPWR VPWR sky130_fd_sc_hd__fill_1
XTAP_TAPCELL_ROW_27_313 VGND VPWR sky130_fd_sc_hd__tapvpwrvgnd_1
XFILLER_40_365 VPWR VGND VPWR VGND sky130_ef_sc_hd__decap_12
XTAP_TAPCELL_ROW_10_202 VGND VPWR sky130_fd_sc_hd__tapvpwrvgnd_1
XFILLER_4_277 VGND VGND VPWR VPWR sky130_fd_sc_hd__fill_1
XFILLER_20_82 VGND VGND VPWR VPWR sky130_fd_sc_hd__fill_2
Xhold80 u_fifo.mem\[13\]\[3\] VGND VGND VPWR VPWR net148 sky130_fd_sc_hd__dlygate4sd3_1
Xhold91 u_fifo.mem\[11\]\[4\] VGND VGND VPWR VPWR net159 sky130_fd_sc_hd__dlygate4sd3_1
XTAP_TAPCELL_ROW_33_349 VGND VPWR sky130_fd_sc_hd__tapvpwrvgnd_1
X_1713_ clknet_leaf_2_clk_10mhz _0216_ net57 VGND VGND VPWR VPWR u_fifo.wr_ptr\[1\]
+ sky130_fd_sc_hd__dfrtp_1
X_1575_ clknet_leaf_5_clk_10mhz _0083_ net59 VGND VGND VPWR VPWR u_uart.tx_data_reg\[6\]
+ sky130_fd_sc_hd__dfrtp_1
X_1644_ clknet_leaf_19_clk_10mhz _0147_ VGND VGND VPWR VPWR u_fifo.mem\[6\]\[1\] sky130_fd_sc_hd__dfxtp_1
XFILLER_41_129 VGND VGND VPWR VPWR sky130_fd_sc_hd__decap_4
X_1009_ u_packet_assembler.timer\[3\] u_packet_assembler.timer\[2\] u_packet_assembler.timer\[1\]
+ u_packet_assembler.timer\[0\] VGND VGND VPWR VPWR _0678_ sky130_fd_sc_hd__and4_1
XFILLER_22_321 VPWR VGND VPWR VGND sky130_ef_sc_hd__decap_12
XFILLER_22_365 VPWR VGND VPWR VGND sky130_ef_sc_hd__decap_12
XFILLER_1_225 VPWR VGND VPWR VGND sky130_ef_sc_hd__decap_12
XFILLER_57_251 VGND VGND VPWR VPWR sky130_fd_sc_hd__fill_2
XTAP_TAPCELL_ROW_55_496 VGND VPWR sky130_fd_sc_hd__tapvpwrvgnd_1
X_1360_ u_fifo.mem\[5\]\[7\] _0308_ _0313_ u_fifo.mem\[3\]\[7\] _0384_ VGND VGND VPWR
+ VPWR _0385_ sky130_fd_sc_hd__a221o_1
X_1291_ _0315_ _0321_ _0322_ net118 VGND VGND VPWR VPWR _0323_ sky130_fd_sc_hd__o22a_1
XFILLER_63_265 VPWR VGND VPWR VGND sky130_ef_sc_hd__decap_12
XFILLER_31_184 VGND VGND VPWR VPWR sky130_fd_sc_hd__decap_3
X_1489_ _0459_ _0464_ VGND VGND VPWR VPWR _0276_ sky130_fd_sc_hd__nor2_1
X_1558_ clknet_leaf_19_clk_10mhz _0009_ net25 VGND VGND VPWR VPWR u_max30102_ctrl.clk_div\[13\]
+ sky130_fd_sc_hd__dfrtp_1
X_1627_ clknet_leaf_25_clk_10mhz _0130_ VGND VGND VPWR VPWR u_fifo.mem\[14\]\[0\]
+ sky130_fd_sc_hd__dfxtp_1
XFILLER_54_287 VGND VGND VPWR VPWR sky130_fd_sc_hd__decap_4
XFILLER_54_232 VPWR VGND VPWR VGND sky130_ef_sc_hd__decap_12
XTAP_TAPCELL_ROW_52_477 VGND VPWR sky130_fd_sc_hd__tapvpwrvgnd_1
XFILLER_22_173 VGND VGND VPWR VPWR sky130_fd_sc_hd__decap_3
XFILLER_7_3 VPWR VGND VPWR VGND sky130_ef_sc_hd__decap_12
XFILLER_45_210 VGND VGND VPWR VPWR sky130_fd_sc_hd__fill_1
XFILLER_45_287 VGND VGND VPWR VPWR sky130_fd_sc_hd__fill_1
XFILLER_26_81 VGND VGND VPWR VPWR sky130_fd_sc_hd__decap_3
X_0791_ u_srf_ctrl.timer\[10\] _0505_ u_srf_ctrl.timer\[11\] VGND VGND VPWR VPWR _0506_
+ sky130_fd_sc_hd__a21o_1
X_0860_ _0476_ _0553_ VGND VGND VPWR VPWR _0555_ sky130_fd_sc_hd__nand2_1
XFILLER_9_111 VGND VGND VPWR VPWR sky130_fd_sc_hd__fill_1
X_1412_ u_uart.clk_count\[5\] _0413_ VGND VGND VPWR VPWR _0416_ sky130_fd_sc_hd__or2_1
X_1343_ u_fifo.mem\[1\]\[5\] _0302_ _0310_ u_fifo.mem\[11\]\[5\] _0369_ VGND VGND
+ VPWR VPWR _0370_ sky130_fd_sc_hd__a221o_1
XFILLER_5_361 VPWR VGND VPWR VGND sky130_ef_sc_hd__decap_12
X_1274_ net34 net33 net31 u_fifo.rd_ptr\[3\] VGND VGND VPWR VPWR _0306_ sky130_fd_sc_hd__and4b_4
X_0989_ _0658_ _0661_ _0662_ net71 u_srf_ctrl.state\[3\] VGND VGND VPWR VPWR _0043_
+ sky130_fd_sc_hd__o32a_1
XFILLER_59_335 VGND VGND VPWR VPWR sky130_fd_sc_hd__fill_1
XFILLER_63_57 VPWR VGND VPWR VGND sky130_ef_sc_hd__decap_12
XFILLER_50_290 VGND VGND VPWR VPWR sky130_fd_sc_hd__fill_2
XFILLER_10_154 VGND VGND VPWR VPWR sky130_fd_sc_hd__decap_4
XFILLER_10_187 VGND VGND VPWR VPWR sky130_fd_sc_hd__decap_4
XPHY_EDGE_ROW_25_Left_89 VGND VGND VPWR VPWR sky130_fd_sc_hd__decap_3
XFILLER_53_90 VGND VGND VPWR VPWR sky130_fd_sc_hd__fill_1
XFILLER_33_213 VGND VGND VPWR VPWR sky130_fd_sc_hd__decap_8
X_0912_ u_srf_ctrl.timer\[16\] _0588_ _0590_ VGND VGND VPWR VPWR _0591_ sky130_fd_sc_hd__o21ba_1
X_0774_ _0487_ _0488_ _0489_ _0490_ VGND VGND VPWR VPWR _0491_ sky130_fd_sc_hd__or4_1
X_0843_ net248 _0540_ VGND VGND VPWR VPWR _0009_ sky130_fd_sc_hd__xor2_1
X_1326_ _0474_ u_fifo.mem\[2\]\[4\] _0303_ VGND VGND VPWR VPWR _0354_ sky130_fd_sc_hd__o21ba_1
X_1188_ net149 net36 _0743_ VGND VGND VPWR VPWR _0161_ sky130_fd_sc_hd__mux2_1
X_1257_ net30 _0709_ net29 VGND VGND VPWR VPWR _0293_ sky130_fd_sc_hd__a21boi_1
XTAP_TAPCELL_ROW_19_260 VGND VPWR sky130_fd_sc_hd__tapvpwrvgnd_1
XTAP_TAPCELL_ROW_2_150 VGND VPWR sky130_fd_sc_hd__tapvpwrvgnd_1
XFILLER_15_279 VGND VGND VPWR VPWR sky130_fd_sc_hd__fill_1
XFILLER_23_290 VGND VGND VPWR VPWR sky130_fd_sc_hd__fill_2
Xclkbuf_leaf_19_clk_10mhz clknet_2_2__leaf_clk_10mhz VGND VGND VPWR VPWR clknet_leaf_19_clk_10mhz
+ sky130_fd_sc_hd__clkbuf_8
XFILLER_0_53 VGND VGND VPWR VPWR sky130_fd_sc_hd__decap_3
XFILLER_0_97 VPWR VGND VPWR VGND sky130_ef_sc_hd__decap_12
X_1111_ u_packet_assembler.state\[2\] _0724_ _0729_ VGND VGND VPWR VPWR _0096_ sky130_fd_sc_hd__mux2_1
X_1042_ u_packet_assembler.timer\[13\] _0699_ VGND VGND VPWR VPWR _0701_ sky130_fd_sc_hd__or2_1
XTAP_TAPCELL_ROW_16_241 VGND VPWR sky130_fd_sc_hd__tapvpwrvgnd_1
X_0826_ u_max30102_ctrl.clk_div\[5\] u_max30102_ctrl.clk_div\[4\] u_max30102_ctrl.clk_div\[6\]
+ _0527_ VGND VGND VPWR VPWR _0532_ sky130_fd_sc_hd__and4_1
X_0757_ net177 VGND VGND VPWR VPWR _0005_ sky130_fd_sc_hd__inv_2
XFILLER_0_109 VGND VGND VPWR VPWR sky130_fd_sc_hd__decap_3
XFILLER_56_157 VGND VGND VPWR VPWR sky130_fd_sc_hd__decap_4
X_1309_ u_fifo.mem\[6\]\[2\] _0297_ _0306_ u_fifo.mem\[14\]\[2\] _0334_ VGND VGND
+ VPWR VPWR _0339_ sky130_fd_sc_hd__a221o_1
XFILLER_44_37 VPWR VGND VPWR VGND sky130_ef_sc_hd__decap_12
XFILLER_44_15 VGND VGND VPWR VPWR sky130_fd_sc_hd__decap_6
XTAP_TAPCELL_ROW_39_388 VGND VPWR sky130_fd_sc_hd__tapvpwrvgnd_1
XFILLER_12_238 VGND VGND VPWR VPWR sky130_fd_sc_hd__fill_2
XTAP_TAPCELL_ROW_22_277 VGND VPWR sky130_fd_sc_hd__tapvpwrvgnd_1
XFILLER_47_157 VGND VGND VPWR VPWR sky130_fd_sc_hd__fill_1
XFILLER_18_82 VGND VGND VPWR VPWR sky130_fd_sc_hd__fill_2
XFILLER_11_271 VGND VGND VPWR VPWR sky130_fd_sc_hd__fill_1
XTAP_TAPCELL_ROW_13_222 VGND VPWR sky130_fd_sc_hd__tapvpwrvgnd_1
XFILLER_50_91 VGND VGND VPWR VPWR sky130_fd_sc_hd__fill_1
X_1660_ clknet_leaf_14_clk_10mhz _0163_ VGND VGND VPWR VPWR u_fifo.mem\[4\]\[1\] sky130_fd_sc_hd__dfxtp_1
Xhold209 u_packet_assembler.timer\[13\] VGND VGND VPWR VPWR net277 sky130_fd_sc_hd__dlygate4sd3_1
X_1591_ clknet_leaf_25_clk_10mhz _0094_ net21 VGND VGND VPWR VPWR u_packet_assembler.state\[0\]
+ sky130_fd_sc_hd__dfrtp_1
XFILLER_22_3 VGND VGND VPWR VPWR sky130_fd_sc_hd__decap_8
XFILLER_46_190 VGND VGND VPWR VPWR sky130_fd_sc_hd__decap_6
XTAP_TAPCELL_ROW_36_369 VGND VPWR sky130_fd_sc_hd__tapvpwrvgnd_1
XPHY_EDGE_ROW_28_Left_92 VGND VGND VPWR VPWR sky130_fd_sc_hd__decap_3
X_1025_ u_packet_assembler.timer\[7\] u_packet_assembler.timer\[8\] _0683_ VGND VGND
+ VPWR VPWR _0689_ sky130_fd_sc_hd__and3_1
XFILLER_14_29 VGND VGND VPWR VPWR sky130_fd_sc_hd__fill_2
X_0809_ u_max30102_ctrl.clk_div\[9\] u_max30102_ctrl.clk_div\[8\] u_max30102_ctrl.clk_div\[11\]
+ u_max30102_ctrl.clk_div\[10\] VGND VGND VPWR VPWR _0520_ sky130_fd_sc_hd__or4_1
XPHY_EDGE_ROW_12_Left_76 VGND VGND VPWR VPWR sky130_fd_sc_hd__decap_3
XTAP_TAPCELL_ROW_27_314 VGND VPWR sky130_fd_sc_hd__tapvpwrvgnd_1
XTAP_TAPCELL_ROW_10_203 VGND VPWR sky130_fd_sc_hd__tapvpwrvgnd_1
Xhold81 u_fifo.mem\[5\]\[7\] VGND VGND VPWR VPWR net149 sky130_fd_sc_hd__dlygate4sd3_1
Xhold70 u_fifo.mem\[10\]\[4\] VGND VGND VPWR VPWR net138 sky130_fd_sc_hd__dlygate4sd3_1
Xhold92 u_fifo.mem\[11\]\[5\] VGND VGND VPWR VPWR net160 sky130_fd_sc_hd__dlygate4sd3_1
XFILLER_45_91 VGND VGND VPWR VPWR sky130_fd_sc_hd__fill_2
XFILLER_28_190 VGND VGND VPWR VPWR sky130_fd_sc_hd__decap_6
X_1712_ clknet_leaf_2_clk_10mhz _0215_ net57 VGND VGND VPWR VPWR u_fifo.wr_ptr\[0\]
+ sky130_fd_sc_hd__dfrtp_1
XFILLER_6_52 VGND VGND VPWR VPWR sky130_fd_sc_hd__decap_4
X_1643_ clknet_leaf_24_clk_10mhz _0146_ VGND VGND VPWR VPWR u_fifo.mem\[6\]\[0\] sky130_fd_sc_hd__dfxtp_1
X_1574_ clknet_leaf_7_clk_10mhz _0082_ net64 VGND VGND VPWR VPWR u_uart.tx_data_reg\[5\]
+ sky130_fd_sc_hd__dfrtp_1
XFILLER_6_85 VGND VGND VPWR VPWR sky130_fd_sc_hd__decap_6
XFILLER_6_74 VGND VGND VPWR VPWR sky130_fd_sc_hd__decap_8
XFILLER_6_63 VGND VGND VPWR VPWR sky130_fd_sc_hd__decap_8
X_1008_ u_packet_assembler.timer\[2\] u_packet_assembler.timer\[1\] u_packet_assembler.timer\[0\]
+ u_packet_assembler.timer\[3\] VGND VGND VPWR VPWR _0677_ sky130_fd_sc_hd__a31o_1
XFILLER_22_333 VPWR VGND VPWR VGND sky130_ef_sc_hd__decap_12
XFILLER_1_237 VPWR VGND VPWR VGND sky130_ef_sc_hd__decap_12
XTAP_TAPCELL_ROW_55_497 VGND VPWR sky130_fd_sc_hd__tapvpwrvgnd_1
XFILLER_17_105 VGND VGND VPWR VPWR sky130_fd_sc_hd__decap_6
XFILLER_25_193 VGND VGND VPWR VPWR sky130_fd_sc_hd__decap_3
XFILLER_40_141 VGND VGND VPWR VPWR sky130_fd_sc_hd__decap_3
XFILLER_9_337 VPWR VGND VPWR VGND sky130_ef_sc_hd__decap_12
Xoutput3 net3 VGND VGND VPWR VPWR led_status[0] sky130_fd_sc_hd__buf_2
XFILLER_63_233 VPWR VGND VPWR VGND sky130_ef_sc_hd__decap_12
XFILLER_63_222 VGND VGND VPWR VPWR sky130_fd_sc_hd__fill_2
X_1290_ u_fifo.rd_ptr\[1\] _0303_ VGND VGND VPWR VPWR _0322_ sky130_fd_sc_hd__or2_4
XFILLER_0_281 VPWR VGND VPWR VGND sky130_ef_sc_hd__decap_12
XFILLER_63_277 VGND VGND VPWR VPWR sky130_fd_sc_hd__decap_3
XFILLER_31_130 VPWR VGND VPWR VGND sky130_ef_sc_hd__decap_12
XFILLER_23_108 VGND VGND VPWR VPWR sky130_fd_sc_hd__decap_4
X_1626_ clknet_leaf_13_clk_10mhz _0129_ VGND VGND VPWR VPWR u_fifo.mem\[8\]\[7\] sky130_fd_sc_hd__dfxtp_1
X_1488_ _0417_ _0461_ u_uart.bit_index\[2\] VGND VGND VPWR VPWR _0464_ sky130_fd_sc_hd__a21oi_1
X_1557_ clknet_leaf_20_clk_10mhz _0008_ net25 VGND VGND VPWR VPWR u_max30102_ctrl.clk_div\[12\]
+ sky130_fd_sc_hd__dfrtp_1
XFILLER_54_244 VGND VGND VPWR VPWR sky130_fd_sc_hd__decap_8
XFILLER_52_15 VGND VGND VPWR VPWR sky130_fd_sc_hd__decap_8
XFILLER_14_108 VPWR VGND VPWR VGND sky130_ef_sc_hd__decap_12
XTAP_TAPCELL_ROW_52_478 VGND VPWR sky130_fd_sc_hd__tapvpwrvgnd_1
X_0790_ u_srf_ctrl.timer\[8\] _0504_ u_srf_ctrl.timer\[9\] VGND VGND VPWR VPWR _0505_
+ sky130_fd_sc_hd__a21o_1
XFILLER_5_373 VGND VGND VPWR VPWR sky130_fd_sc_hd__decap_4
X_1411_ u_uart.clk_count\[5\] _0413_ VGND VGND VPWR VPWR _0415_ sky130_fd_sc_hd__nand2_1
X_1273_ net34 net33 net31 _0475_ VGND VGND VPWR VPWR _0305_ sky130_fd_sc_hd__and4_4
X_1342_ u_fifo.mem\[14\]\[5\] _0306_ _0311_ u_fifo.mem\[4\]\[5\] VGND VGND VPWR VPWR
+ _0369_ sky130_fd_sc_hd__a22o_1
XFILLER_36_211 VGND VGND VPWR VPWR sky130_fd_sc_hd__decap_3
X_0988_ _0605_ _0648_ _0660_ u_srf_ctrl.state\[3\] VGND VGND VPWR VPWR _0662_ sky130_fd_sc_hd__o31ai_1
X_1609_ clknet_leaf_15_clk_10mhz _0112_ VGND VGND VPWR VPWR u_fifo.mem\[10\]\[6\]
+ sky130_fd_sc_hd__dfxtp_1
XFILLER_47_15 VPWR VGND VPWR VGND sky130_ef_sc_hd__decap_12
XFILLER_27_233 VGND VGND VPWR VPWR sky130_fd_sc_hd__fill_1
XFILLER_27_200 VGND VGND VPWR VPWR sky130_fd_sc_hd__fill_2
XFILLER_63_69 VPWR VGND VPWR VGND sky130_ef_sc_hd__decap_12
XFILLER_42_247 VGND VGND VPWR VPWR sky130_fd_sc_hd__decap_4
XFILLER_50_280 VGND VGND VPWR VPWR sky130_fd_sc_hd__fill_2
XFILLER_6_115 VGND VGND VPWR VPWR sky130_fd_sc_hd__fill_1
XFILLER_2_365 VPWR VGND VPWR VGND sky130_ef_sc_hd__decap_12
XFILLER_2_321 VPWR VGND VPWR VGND sky130_ef_sc_hd__decap_12
XPHY_EDGE_ROW_0_Left_64 VGND VGND VPWR VPWR sky130_fd_sc_hd__decap_3
XFILLER_37_92 VPWR VGND VPWR VGND sky130_ef_sc_hd__decap_12
XFILLER_33_225 VGND VGND VPWR VPWR sky130_fd_sc_hd__fill_2
XTAP_TAPCELL_ROW_5_170 VGND VPWR sky130_fd_sc_hd__tapvpwrvgnd_1
X_0911_ u_srf_ctrl.timer\[16\] u_srf_ctrl.timer\[15\] _0585_ VGND VGND VPWR VPWR _0590_
+ sky130_fd_sc_hd__and3_1
X_0842_ _0540_ _0541_ VGND VGND VPWR VPWR _0008_ sky130_fd_sc_hd__nor2_1
XFILLER_52_3 VPWR VGND VPWR VGND sky130_ef_sc_hd__decap_12
X_0773_ net33 net29 VGND VGND VPWR VPWR _0490_ sky130_fd_sc_hd__xor2_1
XFILLER_56_306 VGND VGND VPWR VPWR sky130_fd_sc_hd__fill_2
X_1325_ net214 _0296_ _0352_ _0353_ VGND VGND VPWR VPWR _0223_ sky130_fd_sc_hd__a22o_1
X_1256_ net30 _0709_ VGND VGND VPWR VPWR _0215_ sky130_fd_sc_hd__xor2_1
XTAP_TAPCELL_ROW_62_540 VGND VPWR sky130_fd_sc_hd__tapvpwrvgnd_1
X_1187_ net143 net38 _0743_ VGND VGND VPWR VPWR _0160_ sky130_fd_sc_hd__mux2_1
XTAP_TAPCELL_ROW_19_261 VGND VPWR sky130_fd_sc_hd__tapvpwrvgnd_1
XFILLER_24_269 VGND VGND VPWR VPWR sky130_fd_sc_hd__fill_1
XFILLER_59_144 VPWR VGND VPWR VGND sky130_ef_sc_hd__decap_12
XFILLER_59_133 VGND VGND VPWR VPWR sky130_fd_sc_hd__fill_2
XFILLER_58_69 VGND VGND VPWR VPWR sky130_fd_sc_hd__decap_4
XFILLER_62_309 VPWR VGND VPWR VGND sky130_ef_sc_hd__decap_12
XFILLER_59_177 VPWR VGND VPWR VGND sky130_ef_sc_hd__decap_12
XFILLER_55_361 VPWR VGND VPWR VGND sky130_ef_sc_hd__decap_12
XTAP_TAPCELL_ROW_2_151 VGND VPWR sky130_fd_sc_hd__tapvpwrvgnd_1
XPHY_EDGE_ROW_36_Left_100 VGND VGND VPWR VPWR sky130_fd_sc_hd__decap_3
XTAP_TAPCELL_ROW_25_297 VGND VPWR sky130_fd_sc_hd__tapvpwrvgnd_1
X_1110_ _0546_ _0663_ _0731_ _0730_ u_packet_assembler.state\[1\] VGND VGND VPWR VPWR
+ _0095_ sky130_fd_sc_hd__a32o_1
XFILLER_46_361 VGND VGND VPWR VPWR sky130_fd_sc_hd__decap_3
X_1041_ net12 _0698_ _0700_ net16 net255 VGND VGND VPWR VPWR _0057_ sky130_fd_sc_hd__a32o_1
XTAP_TAPCELL_ROW_16_242 VGND VPWR sky130_fd_sc_hd__tapvpwrvgnd_1
X_0825_ net251 _0530_ VGND VGND VPWR VPWR _0016_ sky130_fd_sc_hd__xnor2_1
X_0756_ u_fifo.rd_ptr\[3\] VGND VGND VPWR VPWR _0475_ sky130_fd_sc_hd__inv_2
XFILLER_56_147 VGND VGND VPWR VPWR sky130_fd_sc_hd__fill_1
X_1239_ net157 net45 _0285_ VGND VGND VPWR VPWR _0205_ sky130_fd_sc_hd__mux2_1
XFILLER_44_309 VGND VGND VPWR VPWR sky130_fd_sc_hd__decap_6
XTAP_TAPCELL_ROW_39_389 VGND VPWR sky130_fd_sc_hd__tapvpwrvgnd_1
X_1308_ u_fifo.mem\[4\]\[2\] _0311_ _0313_ u_fifo.mem\[3\]\[2\] _0337_ VGND VGND VPWR
+ VPWR _0338_ sky130_fd_sc_hd__a221o_1
XFILLER_60_26 VGND VGND VPWR VPWR sky130_fd_sc_hd__fill_2
XFILLER_44_49 VGND VGND VPWR VPWR sky130_fd_sc_hd__decap_4
XFILLER_44_27 VGND VGND VPWR VPWR sky130_fd_sc_hd__fill_1
XTAP_TAPCELL_ROW_22_278 VGND VPWR sky130_fd_sc_hd__tapvpwrvgnd_1
XFILLER_47_169 VGND VGND VPWR VPWR sky130_fd_sc_hd__fill_2
XFILLER_34_93 VPWR VGND VPWR VGND sky130_ef_sc_hd__decap_12
XFILLER_11_250 VGND VGND VPWR VPWR sky130_fd_sc_hd__fill_2
XTAP_TAPCELL_ROW_13_223 VGND VPWR sky130_fd_sc_hd__tapvpwrvgnd_1
XFILLER_50_81 VGND VGND VPWR VPWR sky130_fd_sc_hd__decap_3
X_1590_ clknet_leaf_2_clk_10mhz _0021_ net21 VGND VGND VPWR VPWR fifo_wr_en sky130_fd_sc_hd__dfrtp_1
XFILLER_53_128 VPWR VGND VPWR VGND sky130_ef_sc_hd__decap_12
XFILLER_38_147 VGND VGND VPWR VPWR sky130_fd_sc_hd__fill_1
X_1024_ u_packet_assembler.timer\[7\] _0683_ u_packet_assembler.timer\[8\] VGND VGND
+ VPWR VPWR _0688_ sky130_fd_sc_hd__a21o_1
XFILLER_19_361 VPWR VGND VPWR VGND sky130_ef_sc_hd__decap_12
XFILLER_14_19 VGND VGND VPWR VPWR sky130_fd_sc_hd__fill_2
X_0808_ u_max30102_ctrl.clk_div\[5\] u_max30102_ctrl.clk_div\[4\] u_max30102_ctrl.clk_div\[7\]
+ u_max30102_ctrl.clk_div\[6\] VGND VGND VPWR VPWR _0519_ sky130_fd_sc_hd__or4_1
XFILLER_29_169 VPWR VGND VPWR VGND sky130_ef_sc_hd__decap_12
XTAP_TAPCELL_ROW_27_315 VGND VPWR sky130_fd_sc_hd__tapvpwrvgnd_1
XFILLER_52_194 VGND VGND VPWR VPWR sky130_fd_sc_hd__fill_2
XTAP_TAPCELL_ROW_10_204 VGND VPWR sky130_fd_sc_hd__tapvpwrvgnd_1
XFILLER_4_235 VGND VGND VPWR VPWR sky130_fd_sc_hd__fill_2
XFILLER_4_224 VGND VGND VPWR VPWR sky130_fd_sc_hd__decap_3
Xhold71 u_fifo.mem\[12\]\[5\] VGND VGND VPWR VPWR net139 sky130_fd_sc_hd__dlygate4sd3_1
Xhold82 u_fifo.mem\[3\]\[4\] VGND VGND VPWR VPWR net150 sky130_fd_sc_hd__dlygate4sd3_1
Xhold93 u_fifo.mem\[15\]\[7\] VGND VGND VPWR VPWR net161 sky130_fd_sc_hd__dlygate4sd3_1
Xhold60 u_fifo.mem\[8\]\[2\] VGND VGND VPWR VPWR net128 sky130_fd_sc_hd__dlygate4sd3_1
XFILLER_35_128 VGND VGND VPWR VPWR sky130_fd_sc_hd__fill_1
XFILLER_29_93 VGND VGND VPWR VPWR sky130_fd_sc_hd__decap_4
XFILLER_29_60 VPWR VGND VPWR VGND sky130_ef_sc_hd__decap_12
XFILLER_31_323 VPWR VGND VPWR VGND sky130_ef_sc_hd__decap_12
X_1642_ clknet_leaf_16_clk_10mhz _0145_ VGND VGND VPWR VPWR u_fifo.mem\[7\]\[7\] sky130_fd_sc_hd__dfxtp_1
X_1711_ clknet_leaf_3_clk_10mhz _0214_ net60 VGND VGND VPWR VPWR u_fifo.rd_ptr\[4\]
+ sky130_fd_sc_hd__dfrtp_1
X_1573_ clknet_leaf_7_clk_10mhz _0081_ net64 VGND VGND VPWR VPWR u_uart.tx_data_reg\[4\]
+ sky130_fd_sc_hd__dfrtp_1
XFILLER_34_161 VGND VGND VPWR VPWR sky130_fd_sc_hd__fill_1
X_1007_ net12 _0675_ _0676_ net16 net278 VGND VGND VPWR VPWR _0047_ sky130_fd_sc_hd__a32o_1
XFILLER_22_301 VGND VGND VPWR VPWR sky130_fd_sc_hd__decap_6
XFILLER_22_345 VPWR VGND VPWR VGND sky130_ef_sc_hd__decap_12
XFILLER_1_205 VPWR VGND VPWR VGND sky130_ef_sc_hd__decap_12
XFILLER_1_249 VPWR VGND VPWR VGND sky130_ef_sc_hd__decap_12
XFILLER_57_275 VGND VGND VPWR VPWR sky130_fd_sc_hd__decap_4
XFILLER_40_120 VGND VGND VPWR VPWR sky130_fd_sc_hd__fill_1
XFILLER_40_197 VPWR VGND VPWR VGND sky130_ef_sc_hd__decap_12
XFILLER_31_83 VPWR VGND VPWR VGND sky130_ef_sc_hd__decap_12
XFILLER_9_349 VPWR VGND VPWR VGND sky130_ef_sc_hd__decap_12
Xoutput4 net4 VGND VGND VPWR VPWR led_status[1] sky130_fd_sc_hd__buf_2
XFILLER_63_245 VGND VGND VPWR VPWR sky130_fd_sc_hd__decap_6
XFILLER_0_293 VPWR VGND VPWR VGND sky130_ef_sc_hd__decap_12
XFILLER_31_164 VGND VGND VPWR VPWR sky130_fd_sc_hd__decap_4
XFILLER_31_142 VGND VGND VPWR VPWR sky130_fd_sc_hd__decap_8
X_1625_ clknet_leaf_17_clk_10mhz _0128_ VGND VGND VPWR VPWR u_fifo.mem\[8\]\[6\] sky130_fd_sc_hd__dfxtp_1
X_1556_ clknet_leaf_20_clk_10mhz _0007_ net24 VGND VGND VPWR VPWR u_max30102_ctrl.clk_div\[11\]
+ sky130_fd_sc_hd__dfrtp_1
X_1487_ u_uart.bit_index\[1\] _0462_ _0463_ VGND VGND VPWR VPWR _0275_ sky130_fd_sc_hd__o21ba_1
XFILLER_22_197 VGND VGND VPWR VPWR sky130_fd_sc_hd__decap_6
XFILLER_9_113 VPWR VGND VPWR VGND sky130_ef_sc_hd__decap_12
X_1410_ _0406_ _0413_ _0414_ VGND VGND VPWR VPWR _0247_ sky130_fd_sc_hd__nor3_1
X_1341_ u_fifo.mem\[15\]\[5\] _0291_ _0297_ u_fifo.mem\[6\]\[5\] _0367_ VGND VGND
+ VPWR VPWR _0368_ sky130_fd_sc_hd__a221o_1
XFILLER_36_201 VGND VGND VPWR VPWR sky130_fd_sc_hd__fill_1
XTAP_TAPCELL_ROW_8_190 VGND VPWR sky130_fd_sc_hd__tapvpwrvgnd_1
X_1272_ _0474_ u_fifo.mem\[2\]\[0\] _0303_ VGND VGND VPWR VPWR _0304_ sky130_fd_sc_hd__o21ba_1
X_0987_ _0605_ _0648_ _0660_ VGND VGND VPWR VPWR _0661_ sky130_fd_sc_hd__o21a_1
XFILLER_22_19 VGND VGND VPWR VPWR sky130_fd_sc_hd__decap_8
XFILLER_59_337 VPWR VGND VPWR VGND sky130_ef_sc_hd__decap_12
X_1608_ clknet_leaf_17_clk_10mhz _0111_ VGND VGND VPWR VPWR u_fifo.mem\[10\]\[5\]
+ sky130_fd_sc_hd__dfxtp_1
X_1539_ clknet_leaf_20_clk_10mhz _0064_ net25 VGND VGND VPWR VPWR u_packet_assembler.timer\[19\]
+ sky130_fd_sc_hd__dfrtp_1
XFILLER_63_15 VPWR VGND VPWR VGND sky130_ef_sc_hd__decap_12
XTAP_TAPCELL_ROW_57_505 VGND VPWR sky130_fd_sc_hd__tapvpwrvgnd_1
XFILLER_47_27 VGND VGND VPWR VPWR sky130_fd_sc_hd__fill_2
XFILLER_27_223 VGND VGND VPWR VPWR sky130_fd_sc_hd__fill_1
XFILLER_42_204 VGND VGND VPWR VPWR sky130_fd_sc_hd__decap_3
XFILLER_6_138 VGND VGND VPWR VPWR sky130_fd_sc_hd__fill_2
XFILLER_12_85 VPWR VGND VPWR VGND sky130_ef_sc_hd__decap_12
XTAP_TAPCELL_ROW_5_171 VGND VPWR sky130_fd_sc_hd__tapvpwrvgnd_1
XFILLER_2_333 VPWR VGND VPWR VGND sky130_ef_sc_hd__decap_12
Xhold190 u_max30102_ctrl.clk_div\[9\] VGND VGND VPWR VPWR net258 sky130_fd_sc_hd__dlygate4sd3_1
XFILLER_37_71 VGND VGND VPWR VPWR sky130_fd_sc_hd__decap_3
XPHY_EDGE_ROW_16_Right_16 VGND VGND VPWR VPWR sky130_fd_sc_hd__decap_3
X_0772_ u_fifo.rd_ptr\[3\] u_fifo.wr_ptr\[3\] VGND VGND VPWR VPWR _0489_ sky130_fd_sc_hd__xor2_1
X_0910_ net9 _0587_ _0589_ net19 u_srf_ctrl.timer\[15\] VGND VGND VPWR VPWR _0037_
+ sky130_fd_sc_hd__a32o_1
X_0841_ net261 _0538_ VGND VGND VPWR VPWR _0541_ sky130_fd_sc_hd__nor2_1
XPHY_EDGE_ROW_25_Right_25 VGND VGND VPWR VPWR sky130_fd_sc_hd__decap_3
XFILLER_45_3 VGND VGND VPWR VPWR sky130_fd_sc_hd__decap_3
X_1186_ net190 net41 _0743_ VGND VGND VPWR VPWR _0159_ sky130_fd_sc_hd__mux2_1
X_1324_ u_fifo.mem\[0\]\[3\] _0322_ _0286_ net61 VGND VGND VPWR VPWR _0353_ sky130_fd_sc_hd__o211a_1
X_1255_ net240 _0292_ VGND VGND VPWR VPWR _0214_ sky130_fd_sc_hd__xnor2_1
XPHY_EDGE_ROW_34_Right_34 VGND VGND VPWR VPWR sky130_fd_sc_hd__decap_3
Xclkbuf_leaf_1_clk_10mhz clknet_2_0__leaf_clk_10mhz VGND VGND VPWR VPWR clknet_leaf_1_clk_10mhz
+ sky130_fd_sc_hd__clkbuf_8
XTAP_TAPCELL_ROW_62_541 VGND VPWR sky130_fd_sc_hd__tapvpwrvgnd_1
XTAP_TAPCELL_ROW_19_262 VGND VPWR sky130_fd_sc_hd__tapvpwrvgnd_1
XFILLER_24_248 VGND VGND VPWR VPWR sky130_fd_sc_hd__decap_4
XPHY_EDGE_ROW_43_Right_43 VGND VGND VPWR VPWR sky130_fd_sc_hd__decap_3
XFILLER_59_156 VPWR VGND VPWR VGND sky130_ef_sc_hd__decap_12
XPHY_EDGE_ROW_52_Right_52 VGND VGND VPWR VPWR sky130_fd_sc_hd__decap_3
XFILLER_59_189 VGND VGND VPWR VPWR sky130_fd_sc_hd__decap_6
XFILLER_55_373 VGND VGND VPWR VPWR sky130_fd_sc_hd__decap_4
XTAP_TAPCELL_ROW_2_152 VGND VPWR sky130_fd_sc_hd__tapvpwrvgnd_1
XPHY_EDGE_ROW_61_Right_61 VGND VGND VPWR VPWR sky130_fd_sc_hd__decap_3
XTAP_TAPCELL_ROW_25_298 VGND VPWR sky130_fd_sc_hd__tapvpwrvgnd_1
XFILLER_2_141 VGND VGND VPWR VPWR sky130_fd_sc_hd__decap_8
X_1040_ _0699_ VGND VGND VPWR VPWR _0700_ sky130_fd_sc_hd__inv_2
XTAP_TAPCELL_ROW_16_243 VGND VPWR sky130_fd_sc_hd__tapvpwrvgnd_1
X_0755_ net33 VGND VGND VPWR VPWR _0474_ sky130_fd_sc_hd__inv_2
X_0824_ _0530_ _0531_ VGND VGND VPWR VPWR _0015_ sky130_fd_sc_hd__and2_1
X_1238_ net135 net47 _0285_ VGND VGND VPWR VPWR _0204_ sky130_fd_sc_hd__mux2_1
X_1169_ net90 net39 _0741_ VGND VGND VPWR VPWR _0144_ sky130_fd_sc_hd__mux2_1
X_1307_ u_fifo.mem\[15\]\[2\] _0291_ _0310_ u_fifo.mem\[11\]\[2\] VGND VGND VPWR VPWR
+ _0337_ sky130_fd_sc_hd__a22o_1
XFILLER_29_329 VGND VGND VPWR VPWR sky130_fd_sc_hd__decap_6
XFILLER_60_49 VPWR VGND VPWR VGND sky130_ef_sc_hd__decap_12
XFILLER_52_365 VPWR VGND VPWR VGND sky130_ef_sc_hd__decap_12
XFILLER_12_218 VGND VGND VPWR VPWR sky130_fd_sc_hd__decap_8
XTAP_TAPCELL_ROW_22_279 VGND VPWR sky130_fd_sc_hd__tapvpwrvgnd_1
XFILLER_47_137 VGND VGND VPWR VPWR sky130_fd_sc_hd__decap_4
XFILLER_18_51 VPWR VGND VPWR VGND sky130_ef_sc_hd__decap_12
XFILLER_55_181 VGND VGND VPWR VPWR sky130_fd_sc_hd__decap_3
XFILLER_43_310 VGND VGND VPWR VPWR sky130_fd_sc_hd__fill_1
XTAP_TAPCELL_ROW_13_224 VGND VPWR sky130_fd_sc_hd__tapvpwrvgnd_1
XFILLER_7_222 VGND VGND VPWR VPWR sky130_fd_sc_hd__fill_2
XFILLER_7_266 VPWR VGND VPWR VGND sky130_ef_sc_hd__decap_12
XFILLER_7_288 VGND VGND VPWR VPWR sky130_fd_sc_hd__decap_4
X_1023_ net13 _0686_ _0687_ net18 u_packet_assembler.timer\[7\] VGND VGND VPWR VPWR
+ _0052_ sky130_fd_sc_hd__a32o_1
XFILLER_19_373 VGND VGND VPWR VPWR sky130_fd_sc_hd__decap_4
XFILLER_34_365 VPWR VGND VPWR VGND sky130_ef_sc_hd__decap_12
XPHY_EDGE_ROW_55_Left_119 VGND VGND VPWR VPWR sky130_fd_sc_hd__decap_3
XFILLER_30_19 VGND VGND VPWR VPWR sky130_fd_sc_hd__fill_1
X_0807_ net53 net69 VGND VGND VPWR VPWR u_max30102_ctrl.rst_n sky130_fd_sc_hd__and2_1
XFILLER_29_159 VGND VGND VPWR VPWR sky130_fd_sc_hd__decap_8
XPHY_EDGE_ROW_2_Right_2 VGND VGND VPWR VPWR sky130_fd_sc_hd__decap_3
XFILLER_55_27 VPWR VGND VPWR VGND sky130_ef_sc_hd__decap_12
XFILLER_37_181 VGND VGND VPWR VPWR sky130_fd_sc_hd__fill_1
XFILLER_25_376 VGND VGND VPWR VPWR sky130_fd_sc_hd__fill_1
XTAP_TAPCELL_ROW_10_205 VGND VPWR sky130_fd_sc_hd__tapvpwrvgnd_1
XFILLER_20_85 VPWR VGND VPWR VGND sky130_ef_sc_hd__decap_12
Xhold94 fifo_dout\[5\] VGND VGND VPWR VPWR net162 sky130_fd_sc_hd__dlygate4sd3_1
Xhold50 u_fifo.mem\[0\]\[0\] VGND VGND VPWR VPWR net118 sky130_fd_sc_hd__dlygate4sd3_1
Xhold72 u_fifo.mem\[5\]\[3\] VGND VGND VPWR VPWR net140 sky130_fd_sc_hd__dlygate4sd3_1
Xhold61 u_fifo.mem\[6\]\[5\] VGND VGND VPWR VPWR net129 sky130_fd_sc_hd__dlygate4sd3_1
Xhold83 u_max30102_ctrl.clk_div\[15\] VGND VGND VPWR VPWR net151 sky130_fd_sc_hd__dlygate4sd3_1
XFILLER_31_335 VGND VGND VPWR VPWR sky130_fd_sc_hd__fill_1
XFILLER_31_313 VGND VGND VPWR VPWR sky130_fd_sc_hd__fill_2
XFILLER_16_365 VPWR VGND VPWR VGND sky130_ef_sc_hd__decap_12
X_1572_ clknet_leaf_5_clk_10mhz _0080_ net62 VGND VGND VPWR VPWR u_uart.tx_data_reg\[3\]
+ sky130_fd_sc_hd__dfrtp_1
X_1641_ clknet_leaf_10_clk_10mhz _0144_ VGND VGND VPWR VPWR u_fifo.mem\[7\]\[6\] sky130_fd_sc_hd__dfxtp_1
X_1710_ clknet_leaf_9_clk_10mhz _0213_ net61 VGND VGND VPWR VPWR u_fifo.rd_ptr\[3\]
+ sky130_fd_sc_hd__dfrtp_4
XFILLER_6_98 VGND VGND VPWR VPWR sky130_fd_sc_hd__fill_1
XFILLER_34_173 VGND VGND VPWR VPWR sky130_fd_sc_hd__fill_2
X_1006_ u_packet_assembler.timer\[2\] u_packet_assembler.timer\[1\] u_packet_assembler.timer\[0\]
+ VGND VGND VPWR VPWR _0676_ sky130_fd_sc_hd__nand3_1
XFILLER_34_195 VGND VGND VPWR VPWR sky130_fd_sc_hd__fill_1
XFILLER_22_357 VGND VGND VPWR VPWR sky130_fd_sc_hd__decap_6
XFILLER_1_217 VGND VGND VPWR VPWR sky130_fd_sc_hd__decap_6
XFILLER_57_232 VGND VGND VPWR VPWR sky130_fd_sc_hd__decap_4
XFILLER_13_335 VGND VGND VPWR VPWR sky130_fd_sc_hd__fill_1
XFILLER_31_95 VGND VGND VPWR VPWR sky130_fd_sc_hd__decap_3
Xoutput5 net5 VGND VGND VPWR VPWR led_status[2] sky130_fd_sc_hd__buf_2
XFILLER_56_70 VGND VGND VPWR VPWR sky130_fd_sc_hd__fill_1
XFILLER_48_287 VGND VGND VPWR VPWR sky130_fd_sc_hd__decap_4
XTAP_TAPCELL_ROW_46_433 VGND VPWR sky130_fd_sc_hd__tapvpwrvgnd_1
XFILLER_31_110 VGND VGND VPWR VPWR sky130_fd_sc_hd__fill_2
XFILLER_16_195 VGND VGND VPWR VPWR sky130_fd_sc_hd__fill_1
X_1624_ clknet_leaf_12_clk_10mhz _0127_ VGND VGND VPWR VPWR u_fifo.mem\[8\]\[5\] sky130_fd_sc_hd__dfxtp_1
X_1555_ clknet_leaf_22_clk_10mhz _0006_ net24 VGND VGND VPWR VPWR u_max30102_ctrl.clk_div\[10\]
+ sky130_fd_sc_hd__dfrtp_1
X_1486_ _0417_ _0418_ _0459_ _0461_ VGND VGND VPWR VPWR _0463_ sky130_fd_sc_hd__o22a_1
XFILLER_54_224 VGND VGND VPWR VPWR sky130_fd_sc_hd__fill_1
XFILLER_54_213 VGND VGND VPWR VPWR sky130_fd_sc_hd__fill_2
XFILLER_10_305 VGND VGND VPWR VPWR sky130_fd_sc_hd__decap_3
XFILLER_10_338 VPWR VGND VPWR VGND sky130_ef_sc_hd__decap_12
XFILLER_45_268 VPWR VGND VPWR VGND sky130_ef_sc_hd__decap_12
XTAP_TAPCELL_ROW_43_414 VGND VPWR sky130_fd_sc_hd__tapvpwrvgnd_1
XFILLER_9_125 VPWR VGND VPWR VGND sky130_ef_sc_hd__decap_12
X_1340_ u_fifo.mem\[7\]\[5\] _0305_ _0309_ u_fifo.mem\[9\]\[5\] VGND VGND VPWR VPWR
+ _0367_ sky130_fd_sc_hd__a22o_1
X_1271_ net34 net31 u_fifo.rd_ptr\[3\] VGND VGND VPWR VPWR _0303_ sky130_fd_sc_hd__or3_4
XFILLER_36_235 VGND VGND VPWR VPWR sky130_fd_sc_hd__fill_1
XFILLER_3_55 VGND VGND VPWR VPWR sky130_fd_sc_hd__fill_1
XTAP_TAPCELL_ROW_8_191 VGND VPWR sky130_fd_sc_hd__tapvpwrvgnd_1
X_0986_ _0602_ _0659_ VGND VGND VPWR VPWR _0660_ sky130_fd_sc_hd__xnor2_1
XFILLER_59_349 VPWR VGND VPWR VGND sky130_ef_sc_hd__decap_12
X_1607_ clknet_leaf_11_clk_10mhz _0110_ VGND VGND VPWR VPWR u_fifo.mem\[10\]\[4\]
+ sky130_fd_sc_hd__dfxtp_1
X_1469_ u_srf_ctrl.echo_counter\[11\] _0450_ _0451_ VGND VGND VPWR VPWR _0269_ sky130_fd_sc_hd__a21o_1
X_1538_ clknet_leaf_20_clk_10mhz _0063_ net25 VGND VGND VPWR VPWR u_packet_assembler.timer\[18\]
+ sky130_fd_sc_hd__dfrtp_1
XFILLER_63_27 VGND VGND VPWR VPWR sky130_fd_sc_hd__fill_1
XTAP_TAPCELL_ROW_57_506 VGND VPWR sky130_fd_sc_hd__tapvpwrvgnd_1
XFILLER_10_113 VGND VGND VPWR VPWR sky130_fd_sc_hd__fill_2
XFILLER_5_3 VPWR VGND VPWR VGND sky130_ef_sc_hd__decap_12
XFILLER_2_345 VPWR VGND VPWR VGND sky130_ef_sc_hd__decap_12
XFILLER_12_42 VGND VGND VPWR VPWR sky130_fd_sc_hd__decap_4
XFILLER_12_97 VGND VGND VPWR VPWR sky130_fd_sc_hd__decap_8
Xhold180 u_max30102_ctrl.clk_div\[13\] VGND VGND VPWR VPWR net248 sky130_fd_sc_hd__dlygate4sd3_1
Xhold191 u_srf_ctrl.timer\[0\] VGND VGND VPWR VPWR net259 sky130_fd_sc_hd__dlygate4sd3_1
XTAP_TAPCELL_ROW_5_172 VGND VPWR sky130_fd_sc_hd__tapvpwrvgnd_1
XFILLER_18_246 VGND VGND VPWR VPWR sky130_fd_sc_hd__fill_1
XFILLER_53_82 VGND VGND VPWR VPWR sky130_fd_sc_hd__decap_8
XFILLER_41_293 VGND VGND VPWR VPWR sky130_fd_sc_hd__fill_1
X_0771_ net30 net35 VGND VGND VPWR VPWR _0488_ sky130_fd_sc_hd__xor2_1
X_0840_ u_max30102_ctrl.clk_div\[12\] _0538_ VGND VGND VPWR VPWR _0540_ sky130_fd_sc_hd__and2_1
X_1323_ u_fifo.mem\[11\]\[3\] _0310_ _0345_ _0351_ VGND VGND VPWR VPWR _0352_ sky130_fd_sc_hd__a211o_1
X_1185_ net132 net42 _0743_ VGND VGND VPWR VPWR _0158_ sky130_fd_sc_hd__mux2_1
Xclkbuf_leaf_5_clk_10mhz clknet_2_1__leaf_clk_10mhz VGND VGND VPWR VPWR clknet_leaf_5_clk_10mhz
+ sky130_fd_sc_hd__clkbuf_8
X_1254_ _0475_ _0289_ VGND VGND VPWR VPWR _0213_ sky130_fd_sc_hd__xnor2_1
XTAP_TAPCELL_ROW_19_263 VGND VPWR sky130_fd_sc_hd__tapvpwrvgnd_1
XTAP_TAPCELL_ROW_62_542 VGND VPWR sky130_fd_sc_hd__tapvpwrvgnd_1
XFILLER_32_293 VGND VGND VPWR VPWR sky130_fd_sc_hd__fill_1
X_0969_ _0636_ _0642_ VGND VGND VPWR VPWR _0643_ sky130_fd_sc_hd__xnor2_1
XFILLER_59_113 VGND VGND VPWR VPWR sky130_fd_sc_hd__fill_1
XFILLER_58_27 VGND VGND VPWR VPWR sky130_fd_sc_hd__fill_1
XTAP_TAPCELL_ROW_2_153 VGND VPWR sky130_fd_sc_hd__tapvpwrvgnd_1
XFILLER_15_205 VGND VGND VPWR VPWR sky130_fd_sc_hd__fill_1
XFILLER_23_85 VPWR VGND VPWR VGND sky130_ef_sc_hd__decap_12
XTAP_TAPCELL_ROW_25_299 VGND VPWR sky130_fd_sc_hd__tapvpwrvgnd_1
XFILLER_2_197 VPWR VGND VPWR VGND sky130_ef_sc_hd__decap_12
XFILLER_58_190 VGND VGND VPWR VPWR sky130_fd_sc_hd__decap_6
XFILLER_48_82 VGND VGND VPWR VPWR sky130_fd_sc_hd__fill_2
XFILLER_61_333 VGND VGND VPWR VPWR sky130_fd_sc_hd__decap_3
XTAP_TAPCELL_ROW_16_244 VGND VPWR sky130_fd_sc_hd__tapvpwrvgnd_1
X_0754_ u_uart.bit_index\[1\] VGND VGND VPWR VPWR _0473_ sky130_fd_sc_hd__inv_2
X_0823_ u_max30102_ctrl.clk_div\[4\] _0527_ VGND VGND VPWR VPWR _0531_ sky130_fd_sc_hd__or2_1
X_1306_ u_fifo.mem\[5\]\[2\] _0308_ _0312_ u_fifo.mem\[13\]\[2\] _0335_ VGND VGND
+ VPWR VPWR _0336_ sky130_fd_sc_hd__a221o_1
X_1237_ net77 net49 _0285_ VGND VGND VPWR VPWR _0203_ sky130_fd_sc_hd__mux2_1
X_1168_ net83 net40 _0741_ VGND VGND VPWR VPWR _0143_ sky130_fd_sc_hd__mux2_1
X_1099_ u_packet_assembler.state\[1\] _0720_ _0724_ _0725_ VGND VGND VPWR VPWR _0726_
+ sky130_fd_sc_hd__a22o_1
XFILLER_47_149 VGND VGND VPWR VPWR sky130_fd_sc_hd__decap_8
XFILLER_18_41 VGND VGND VPWR VPWR sky130_fd_sc_hd__decap_4
XFILLER_18_63 VGND VGND VPWR VPWR sky130_fd_sc_hd__decap_4
XFILLER_18_85 VGND VGND VPWR VPWR sky130_fd_sc_hd__decap_4
XFILLER_11_230 VPWR VGND VPWR VGND sky130_ef_sc_hd__decap_12
XFILLER_7_278 VGND VGND VPWR VPWR sky130_fd_sc_hd__fill_2
XFILLER_11_263 VGND VGND VPWR VPWR sky130_fd_sc_hd__decap_8
XFILLER_59_92 VPWR VGND VPWR VGND sky130_ef_sc_hd__decap_12
X_1022_ u_packet_assembler.timer\[7\] _0683_ VGND VGND VPWR VPWR _0687_ sky130_fd_sc_hd__or2_1
X_0806_ _0476_ _0511_ _0518_ VGND VGND VPWR VPWR _0001_ sky130_fd_sc_hd__o21ai_1
XFILLER_40_325 VGND VGND VPWR VPWR sky130_fd_sc_hd__decap_3
XFILLER_37_193 VGND VGND VPWR VPWR sky130_fd_sc_hd__decap_3
Xhold40 u_fifo.mem\[12\]\[3\] VGND VGND VPWR VPWR net108 sky130_fd_sc_hd__dlygate4sd3_1
XFILLER_20_97 VGND VGND VPWR VPWR sky130_fd_sc_hd__decap_8
Xhold84 u_fifo.mem\[5\]\[2\] VGND VGND VPWR VPWR net152 sky130_fd_sc_hd__dlygate4sd3_1
Xhold73 u_fifo.mem\[8\]\[0\] VGND VGND VPWR VPWR net141 sky130_fd_sc_hd__dlygate4sd3_1
Xhold95 u_fifo.mem\[4\]\[3\] VGND VGND VPWR VPWR net163 sky130_fd_sc_hd__dlygate4sd3_1
Xhold51 u_fifo.mem\[10\]\[1\] VGND VGND VPWR VPWR net119 sky130_fd_sc_hd__dlygate4sd3_1
XFILLER_45_61 VGND VGND VPWR VPWR sky130_fd_sc_hd__fill_1
XFILLER_35_108 VGND VGND VPWR VPWR sky130_fd_sc_hd__decap_4
Xhold62 u_fifo.mem\[6\]\[6\] VGND VGND VPWR VPWR net130 sky130_fd_sc_hd__dlygate4sd3_1
XFILLER_43_196 VGND VGND VPWR VPWR sky130_fd_sc_hd__fill_2
X_1571_ clknet_leaf_7_clk_10mhz _0079_ net64 VGND VGND VPWR VPWR u_uart.tx_data_reg\[2\]
+ sky130_fd_sc_hd__dfrtp_1
X_1640_ clknet_leaf_10_clk_10mhz _0143_ VGND VGND VPWR VPWR u_fifo.mem\[7\]\[5\] sky130_fd_sc_hd__dfxtp_1
XTAP_TAPCELL_ROW_49_453 VGND VPWR sky130_fd_sc_hd__tapvpwrvgnd_1
XFILLER_34_141 VGND VGND VPWR VPWR sky130_fd_sc_hd__decap_6
X_1005_ u_packet_assembler.timer\[1\] u_packet_assembler.timer\[0\] u_packet_assembler.timer\[2\]
+ VGND VGND VPWR VPWR _0675_ sky130_fd_sc_hd__a21o_1
XFILLER_19_193 VGND VGND VPWR VPWR sky130_fd_sc_hd__fill_1
XTAP_TAPCELL_ROW_32_342 VGND VPWR sky130_fd_sc_hd__tapvpwrvgnd_1
X_1769_ clknet_leaf_27_clk_10mhz _0272_ net52 VGND VGND VPWR VPWR u_srf_ctrl.echo_counter\[14\]
+ sky130_fd_sc_hd__dfrtp_1
Xclkbuf_leaf_20_clk_10mhz clknet_2_2__leaf_clk_10mhz VGND VGND VPWR VPWR clknet_leaf_20_clk_10mhz
+ sky130_fd_sc_hd__clkbuf_8
XFILLER_17_119 VGND VGND VPWR VPWR sky130_fd_sc_hd__fill_1
XFILLER_25_141 VGND VGND VPWR VPWR sky130_fd_sc_hd__fill_2
XFILLER_15_86 VGND VGND VPWR VPWR sky130_fd_sc_hd__fill_1
Xoutput6 net6 VGND VGND VPWR VPWR pwr_ctrl sky130_fd_sc_hd__buf_2
XFILLER_48_277 VGND VGND VPWR VPWR sky130_fd_sc_hd__fill_1
XFILLER_63_214 VGND VGND VPWR VPWR sky130_fd_sc_hd__decap_8
XFILLER_56_82 VGND VGND VPWR VPWR sky130_fd_sc_hd__fill_2
XFILLER_48_299 VGND VGND VPWR VPWR sky130_fd_sc_hd__fill_1
XTAP_TAPCELL_ROW_46_434 VGND VPWR sky130_fd_sc_hd__tapvpwrvgnd_1
XFILLER_16_141 VGND VGND VPWR VPWR sky130_fd_sc_hd__decap_4
XFILLER_8_362 VGND VGND VPWR VPWR sky130_fd_sc_hd__fill_2
X_1485_ u_uart.bit_index\[0\] _0461_ _0462_ VGND VGND VPWR VPWR _0274_ sky130_fd_sc_hd__o21ba_1
X_1623_ clknet_leaf_10_clk_10mhz _0126_ VGND VGND VPWR VPWR u_fifo.mem\[8\]\[4\] sky130_fd_sc_hd__dfxtp_1
X_1554_ clknet_leaf_22_clk_10mhz _0020_ net23 VGND VGND VPWR VPWR u_max30102_ctrl.clk_div\[9\]
+ sky130_fd_sc_hd__dfrtp_1
.ends
